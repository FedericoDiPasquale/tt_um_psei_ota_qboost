** sch_path: /foss/designs/modulo6/tt_um_psei_ota_qboost/xschem/otaSys_5t_sky130.sch
**.subckt otaSys_5t_sky130 VDD in out GND
*.opin out
*.ipin in
*.ipin GND
*.ipin VDD
x1 VDD net1 net2 in GND ota_5t_sky130
x2 VDD out net1 net2 GND ota_5t_sky130
x3 VDD net1 net2 out GND ota_5t_sky130
x4 VDD out out net2 GND otaq_5t_sky130
XC1 net1 GND sky130_fd_pr__cap_mim_m3_1 W=30 L=30 MF=4 m=4
XR1 VDD net2 GND sky130_fd_pr__res_high_po_1p41 L=88.83 mult=1
XR2 net2 GND GND sky130_fd_pr__res_high_po_1p41 L=88.83 mult=1
XC2 out GND sky130_fd_pr__cap_mim_m3_1 W=24 L=24 MF=1
XC3 out GND sky130_fd_pr__cap_mim_m3_1 W=24 L=24 MF=1
**.ends

* expanding   symbol:  ota_5t_sky130.sym # of pins=5
** sym_path: /foss/designs/modulo6/tt_um_psei_ota_qboost/xschem/ota_5t_sky130.sym
** sch_path: /foss/designs/modulo6/tt_um_psei_ota_qboost/xschem/ota_5t_sky130.sch
.subckt ota_5t_sky130 VDD VOUT VINP VINN GND
*.ipin VINP
*.ipin VINN
*.opin VOUT
*.ipin VDD
*.ipin GND
XM5 V5 VDD GND GND sky130_fd_pr__nfet_01v8 L=1.475 W=4 nf=1 ad=1.16 as=1.16 pd=8.58 ps=8.58 nrd=0.0725 nrs=0.0725 sa=0 sb=0 sd=0
+ mult=1
XM1 net1 VINP V5 GND sky130_fd_pr__nfet_01v8 L=0.5 W=2 nf=1 ad=0.58 as=0.58 pd=4.58 ps=4.58 nrd=0.145 nrs=0.145 sa=0 sb=0 sd=0
+ mult=1
XM2 VOUT VINN V5 GND sky130_fd_pr__nfet_01v8 L=0.5 W=2 nf=1 ad=0.58 as=0.58 pd=4.58 ps=4.58 nrd=0.145 nrs=0.145 sa=0 sb=0 sd=0
+ mult=1
XM3 net1 net1 VDD VDD sky130_fd_pr__pfet_01v8 L=0.5 W=5 nf=1 ad=1.45 as=1.45 pd=10.58 ps=10.58 nrd=0.058 nrs=0.058 sa=0 sb=0 sd=0
+ mult=1
XM4 VOUT net1 VDD VDD sky130_fd_pr__pfet_01v8 L=0.5 W=5 nf=1 ad=1.45 as=1.45 pd=10.58 ps=10.58 nrd=0.058 nrs=0.058 sa=0 sb=0 sd=0
+ mult=1
XM6 VDD VDD GND GND sky130_fd_pr__nfet_01v8 L=0.5 W=4 nf=1 ad=1.16 as=1.16 pd=8.58 ps=8.58 nrd=0.0725 nrs=0.0725 sa=0 sb=0 sd=0
+ mult=1
.ends

* expanding   symbol:  otaq_5t_sky130.sym # of pins=5
** sym_path: /foss/designs/modulo6/tt_um_psei_ota_qboost/xschem/otaq_5t_sky130.sym
** sch_path: /foss/designs/modulo6/tt_um_psei_ota_qboost/xschem/otaq_5t_sky130.sch
.subckt otaq_5t_sky130 VDD VOUT VINP VINN GND
*.ipin VINP
*.ipin VINN
*.opin VOUT
*.ipin VDD
*.ipin GND
XM5 net2 VDD GND GND sky130_fd_pr__nfet_01v8 L=20 W=0.5 nf=1 ad=0.145 as=0.145 pd=1.58 ps=1.58 nrd=0.58 nrs=0.58 sa=0 sb=0 sd=0
+ mult=1
XM1 net1 VINP net2 GND sky130_fd_pr__nfet_01v8 L=7 W=0.5 nf=1 ad=0.145 as=0.145 pd=1.58 ps=1.58 nrd=0.58 nrs=0.58 sa=0 sb=0 sd=0
+ mult=1
XM2 VOUT VINN net2 GND sky130_fd_pr__nfet_01v8 L=7 W=0.5 nf=1 ad=0.145 as=0.145 pd=1.58 ps=1.58 nrd=0.58 nrs=0.58 sa=0 sb=0 sd=0
+ mult=1
XM3 net1 net1 VDD VDD sky130_fd_pr__pfet_01v8 L=7 W=1 nf=1 ad=0.29 as=0.29 pd=2.58 ps=2.58 nrd=0.29 nrs=0.29 sa=0 sb=0 sd=0 mult=1
XM4 VOUT net1 VDD VDD sky130_fd_pr__pfet_01v8 L=7 W=1 nf=1 ad=0.29 as=0.29 pd=2.58 ps=2.58 nrd=0.29 nrs=0.29 sa=0 sb=0 sd=0 mult=1
XM6 VDD VDD GND GND sky130_fd_pr__nfet_01v8 L=0.5 W=1 nf=1 ad=0.29 as=0.29 pd=2.58 ps=2.58 nrd=0.29 nrs=0.29 sa=0 sb=0 sd=0 mult=1
.ends

.end
