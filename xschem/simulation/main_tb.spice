** sch_path: /foss/designs/modulo6/tt_um_psei_ota_qboost/xschem/main_tb.sch
**.subckt main_tb out
*.opin out
B0 b0 0 V = '(((time-floor(time/200n)*200n)>=50n && (time-floor(time/200n)*200n)<75n) || ((time-floor(time/200n)*200n)>=125n && (time-floor(time/200n)*200n)<150n) || ((time-floor(time/200n)*200n)>=175n && (time-floor(time/200n)*200n)<200n)) ? 1.8 : 0'
B2 b1 0 V = '((time-floor(time/200n)*200n)>=25n && (time-floor(time/200n)*200n)<100n) ? 1.8 : 0'
B3 b2 0 V = '(time-floor(time/200n)*200n)<125n ? 1.8 : 0'
V1 net1 0 1.8
x1 net1 b0 out b1 b2 0 main
**** begin user architecture code
.lib /foss/pdks/sky130A/libs.tech/combined/sky130.lib.spice ss

.control
save all
.param f=5Meg
.param Fs=20Meg
.param Ts={1/Fs}
tran 1n 60000n
write main_tran_ss.raw
op
write main_op.raw
ac dec 20 1 100meg
write main_ac.raw
.endc

**** end user architecture code
**.ends

* expanding   symbol:  main.sym # of pins=6
** sym_path: /foss/designs/modulo6/tt_um_psei_ota_qboost/xschem/main.sym
** sch_path: /foss/designs/modulo6/tt_um_psei_ota_qboost/xschem/main.sch
.subckt main VDD b0 out b1 b2 GND
*.ipin VDD
*.ipin GND
*.ipin b0
*.ipin b1
*.ipin b2
*.opin out
x5 b0 b1 b2 VDD v_dac GND DAC3bit
x1 VDD v_dac out GND otaSys_5t_sky130
.ends

* expanding   symbol:  DAC3bit.sym # of pins=6
** sym_path: /foss/designs/modulo6/tt_um_psei_ota_qboost/xschem/DAC3bit.sym
** sch_path: /foss/designs/modulo6/tt_um_psei_ota_qboost/xschem/DAC3bit.sch
.subckt DAC3bit b0 b1 b2 VDD out GND
*.opin out
*.ipin b0
*.ipin b1
*.ipin b2
*.ipin GND
*.ipin VDD
XR1 GND net3 sky130_fd_pr__res_generic_po W=1 L=21
XR2 net3 net1 sky130_fd_pr__res_generic_po W=1 L=21
XR3 b0 net4 sky130_fd_pr__res_generic_po W=1 L=21
XR4 net4 net1 sky130_fd_pr__res_generic_po W=1 L=21
XR5 b1 net5 sky130_fd_pr__res_generic_po W=1 L=21
XR6 net5 net2 sky130_fd_pr__res_generic_po W=1 L=21
XR7 b2 net6 sky130_fd_pr__res_generic_po W=1 L=21
XR8 net6 vx sky130_fd_pr__res_generic_po W=1 L=21
XR9 net1 net2 sky130_fd_pr__res_generic_po W=1 L=21
XR10 net2 vx sky130_fd_pr__res_generic_po W=1 L=21
XR12 VDD out sky130_fd_pr__res_generic_po W=1 L=21
XR13 out GND sky130_fd_pr__res_generic_po W=1 L=21
XR11 out vx sky130_fd_pr__res_generic_po W=1 L=63
.ends

* expanding   symbol:  otaSys_5t_sky130.sym # of pins=4
** sym_path: /foss/designs/modulo6/tt_um_psei_ota_qboost/xschem/otaSys_5t_sky130.sym
** sch_path: /foss/designs/modulo6/tt_um_psei_ota_qboost/xschem/otaSys_5t_sky130.sch
.subckt otaSys_5t_sky130 VDD in out GND
*.opin out
*.ipin in
*.ipin GND
*.ipin VDD
x1 VDD net1 net2 in GND ota_5t_sky130
x2 VDD out net1 net2 GND ota_5t_sky130
x3 VDD net1 net2 out GND ota_5t_sky130
x4 VDD out out net2 GND otaq_5t_sky130
XC1 net1 GND sky130_fd_pr__cap_mim_m3_1 W=30 L=30 MF=4 m=4
XR1 VDD net2 GND sky130_fd_pr__res_high_po_1p41 L=88.83 mult=1
XR2 net2 GND GND sky130_fd_pr__res_high_po_1p41 L=88.83 mult=1
XC2 out GND sky130_fd_pr__cap_mim_m3_1 W=24 L=24 MF=1
XC3 out GND sky130_fd_pr__cap_mim_m3_1 W=24 L=24 MF=1
.ends

* expanding   symbol:  ota_5t_sky130.sym # of pins=5
** sym_path: /foss/designs/modulo6/tt_um_psei_ota_qboost/xschem/ota_5t_sky130.sym
** sch_path: /foss/designs/modulo6/tt_um_psei_ota_qboost/xschem/ota_5t_sky130.sch
.subckt ota_5t_sky130 VDD VOUT VINP VINN GND
*.ipin VINP
*.ipin VINN
*.opin VOUT
*.ipin VDD
*.ipin GND
XM5 V5 VDD GND GND sky130_fd_pr__nfet_01v8 L=1.475 W=4 nf=1 ad=1.16 as=1.16 pd=8.58 ps=8.58 nrd=0.0725 nrs=0.0725 sa=0 sb=0 sd=0
+ mult=1
XM1 net1 VINP V5 GND sky130_fd_pr__nfet_01v8 L=0.5 W=2 nf=1 ad=0.58 as=0.58 pd=4.58 ps=4.58 nrd=0.145 nrs=0.145 sa=0 sb=0 sd=0
+ mult=1
XM2 VOUT VINN V5 GND sky130_fd_pr__nfet_01v8 L=0.5 W=2 nf=1 ad=0.58 as=0.58 pd=4.58 ps=4.58 nrd=0.145 nrs=0.145 sa=0 sb=0 sd=0
+ mult=1
XM3 net1 net1 VDD VDD sky130_fd_pr__pfet_01v8 L=0.5 W=5 nf=1 ad=1.45 as=1.45 pd=10.58 ps=10.58 nrd=0.058 nrs=0.058 sa=0 sb=0 sd=0
+ mult=1
XM4 VOUT net1 VDD VDD sky130_fd_pr__pfet_01v8 L=0.5 W=5 nf=1 ad=1.45 as=1.45 pd=10.58 ps=10.58 nrd=0.058 nrs=0.058 sa=0 sb=0 sd=0
+ mult=1
XM6 VDD VDD GND GND sky130_fd_pr__nfet_01v8 L=0.5 W=4 nf=1 ad=1.16 as=1.16 pd=8.58 ps=8.58 nrd=0.0725 nrs=0.0725 sa=0 sb=0 sd=0
+ mult=1
.ends

* expanding   symbol:  otaq_5t_sky130.sym # of pins=5
** sym_path: /foss/designs/modulo6/tt_um_psei_ota_qboost/xschem/otaq_5t_sky130.sym
** sch_path: /foss/designs/modulo6/tt_um_psei_ota_qboost/xschem/otaq_5t_sky130.sch
.subckt otaq_5t_sky130 VDD VOUT VINP VINN GND
*.ipin VINP
*.ipin VINN
*.opin VOUT
*.ipin VDD
*.ipin GND
XM5 net2 VDD GND GND sky130_fd_pr__nfet_01v8 L=20 W=0.5 nf=1 ad=0.145 as=0.145 pd=1.58 ps=1.58 nrd=0.58 nrs=0.58 sa=0 sb=0 sd=0
+ mult=1
XM1 net1 VINP net2 GND sky130_fd_pr__nfet_01v8 L=7 W=0.5 nf=1 ad=0.145 as=0.145 pd=1.58 ps=1.58 nrd=0.58 nrs=0.58 sa=0 sb=0 sd=0
+ mult=1
XM2 VOUT VINN net2 GND sky130_fd_pr__nfet_01v8 L=7 W=0.5 nf=1 ad=0.145 as=0.145 pd=1.58 ps=1.58 nrd=0.58 nrs=0.58 sa=0 sb=0 sd=0
+ mult=1
XM3 net1 net1 VDD VDD sky130_fd_pr__pfet_01v8 L=7 W=1 nf=1 ad=0.29 as=0.29 pd=2.58 ps=2.58 nrd=0.29 nrs=0.29 sa=0 sb=0 sd=0 mult=1
XM4 VOUT net1 VDD VDD sky130_fd_pr__pfet_01v8 L=7 W=1 nf=1 ad=0.29 as=0.29 pd=2.58 ps=2.58 nrd=0.29 nrs=0.29 sa=0 sb=0 sd=0 mult=1
XM6 VDD VDD GND GND sky130_fd_pr__nfet_01v8 L=0.5 W=1 nf=1 ad=0.29 as=0.29 pd=2.58 ps=2.58 nrd=0.29 nrs=0.29 sa=0 sb=0 sd=0 mult=1
.ends

.end
