** sch_path: /foss/designs/modulo6/tt_um_psei_ota_qboost/xschem/DAC3bit_tb.sch
**.subckt DAC3bit_tb out
*.opin out
B0 b0 0 V = '(((time-floor(time/200n)*200n)>=50n && (time-floor(time/200n)*200n)<75n) || ((time-floor(time/200n)*200n)>=125n && (time-floor(time/200n)*200n)<150n) || ((time-floor(time/200n)*200n)>=175n && (time-floor(time/200n)*200n)<200n)) ? 1.8 : 0'
B1 b1 0 V = '((time-floor(time/200n)*200n)>=25n && (time-floor(time/200n)*200n)<100n) ? 1.8 : 0'
B2 b2 0 V = '(time-floor(time/200n)*200n)<125n ? 1.8 : 0'
x1 b0 b1 b2 net1 out 0 DAC3bit
V1 net1 0 1.8
**** begin user architecture code
.lib /foss/pdks/sky130A/libs.tech/combined/sky130.lib.spice tt

.control
save all
tran 1n 5u
write DAC3bit_tran.raw
op
write DAC3bit_op.raw
ac dec 20 1k 100meg
write DAC3bit_ac.raw
.endc

**** end user architecture code
**.ends

* expanding   symbol:  DAC3bit.sym # of pins=6
** sym_path: /foss/designs/modulo6/tt_um_psei_ota_qboost/xschem/DAC3bit.sym
** sch_path: /foss/designs/modulo6/tt_um_psei_ota_qboost/xschem/DAC3bit.sch
.subckt DAC3bit b0 b1 b2 VDD out GND
*.opin out
*.ipin b0
*.ipin b1
*.ipin b2
*.ipin GND
*.ipin VDD
XR1 GND net3 sky130_fd_pr__res_generic_po W=1 L=21
XR2 net3 net1 sky130_fd_pr__res_generic_po W=1 L=21
XR3 b0 net4 sky130_fd_pr__res_generic_po W=1 L=21
XR4 net4 net1 sky130_fd_pr__res_generic_po W=1 L=21
XR5 b1 net5 sky130_fd_pr__res_generic_po W=1 L=21
XR6 net5 net2 sky130_fd_pr__res_generic_po W=1 L=21
XR7 b2 net6 sky130_fd_pr__res_generic_po W=1 L=21
XR8 net6 vx sky130_fd_pr__res_generic_po W=1 L=21
XR9 net1 net2 sky130_fd_pr__res_generic_po W=1 L=21
XR10 net2 vx sky130_fd_pr__res_generic_po W=1 L=21
XR12 VDD out sky130_fd_pr__res_generic_po W=1 L=21
XR13 out GND sky130_fd_pr__res_generic_po W=1 L=21
XR11 out vx sky130_fd_pr__res_generic_po W=1 L=63
.ends

.end
