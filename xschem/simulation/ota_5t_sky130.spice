** sch_path: /foss/designs/modulo6/tt_um_psei_ota_qboost/xschem/ota_5t_sky130.sch
.subckt ota_5t_sky130 VDD VOUT VINP VINN GND
*.PININFO VINP:I VINN:I VOUT:O VDD:I GND:I
XM5 V5 VDD net4 GND sky130_fd_pr__nfet_01v8 L=1.475 W=4 nf=1
XM1 net1 VINP net2 GND sky130_fd_pr__nfet_01v8 L=0.5 W=2 nf=1
XM2 VOUT VINN net3 GND sky130_fd_pr__nfet_01v8 L=0.5 W=2 nf=1
XM3 net1 net1 VDD VDD sky130_fd_pr__pfet_01v8 L=0.5 W=5 nf=1
XM4 VOUT net1 VDD VDD sky130_fd_pr__pfet_01v8 L=0.5 W=5 nf=1
XM6 VDD VDD GND GND sky130_fd_pr__nfet_01v8 L=0.5 W=4 nf=1
Vmeas net4 GND 0
.save i(vmeas)
Vmeas1 net2 V5 0
.save i(vmeas1)
Vmeas2 net3 V5 0
.save i(vmeas2)
.ends
