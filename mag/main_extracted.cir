* Extracted by KLayout with SKY130 LVS runset on : 15/08/2026 18:01

* cell main
* pin VDD
* pin b0
* pin b1
* pin b2
* pin out
* pin GND
.SUBCKT main VDD b0 b1 b2 out GND
* cell instance $1 r0 *1 336.18,186.6
X$1 \$2 out VDD GND otaSys_5t_sky130
* cell instance $2 r0 *1 194,230.85
X$2 b2 b1 \$2 VDD b0 GND DAC3bit
.ENDS main

* cell DAC3bit
* pin b2
* pin b1
* pin out
* pin VDD
* pin b0
* pin GND
.SUBCKT DAC3bit b2 b1 out VDD b0 GND
* device instance $1 r0 *1 45.97,-22.98 sky130_fd_pr__res_generic_po
XR$1 \$2 out sky130_fd_pr__res_generic_po R=3036.6 L=63000000 W=1000000
+ A=6.3e+13 P=128000000
* device instance $2 r90 *1 23.43,-44.46 sky130_fd_pr__res_generic_po
XR$2 \$2 b2 sky130_fd_pr__res_generic_po R=2024.4 L=42000000 W=1000000
+ A=4.2e+13 P=88000000
* device instance $3 r0 *1 40.05,-32.58 sky130_fd_pr__res_generic_po
XR$3 \$2 \$5 sky130_fd_pr__res_generic_po R=1012.2 L=21000000 W=1000000
+ A=2.1e+13 P=44000000
* device instance $5 r180 *1 39.91,-2.01 sky130_fd_pr__res_generic_po
XR$5 \$12 \$5 sky130_fd_pr__res_generic_po R=1012.2 L=21000000 W=1000000
+ A=2.1e+13 P=44000000
* device instance $6 r90 *1 23.3,-17.52 sky130_fd_pr__res_generic_po
XR$6 \$5 b1 sky130_fd_pr__res_generic_po R=2024.4 L=42000000 W=1000000
+ A=4.2e+13 P=88000000
* device instance $8 r0 *1 62.03,-31.89 sky130_fd_pr__res_generic_po
XR$8 GND out sky130_fd_pr__res_generic_po R=1012.2 L=21000000 W=1000000
+ A=2.1e+13 P=44000000
* device instance $9 r0 *1 62.12,-2.28 sky130_fd_pr__res_generic_po
XR$9 out VDD sky130_fd_pr__res_generic_po R=1012.2 L=21000000 W=1000000
+ A=2.1e+13 P=44000000
* device instance $10 r270 *1 -6.43,10.26 sky130_fd_pr__res_generic_po
XR$10 b0 \$12 sky130_fd_pr__res_generic_po R=2024.4 L=42000000 W=1000000
+ A=4.2e+13 P=88000000
* device instance $12 r90 *1 23.45,19.89 sky130_fd_pr__res_generic_po
XR$12 \$12 GND sky130_fd_pr__res_generic_po R=2024.4 L=42000000 W=1000000
+ A=4.2e+13 P=88000000
.ENDS DAC3bit

* cell otaSys_5t_sky130
* pin in
* pin out
* pin VDD
* pin GND
.SUBCKT otaSys_5t_sky130 in out VDD GND
* cell instance $1 m90 *1 41.35,24.65
X$1 VDD \$3 out \$2 GND ota_5t_sky130
* cell instance $2 r0 *1 18,-6.2
X$2 VDD \$2 \$3 out GND ota_5t_sky130
* cell instance $4 r0 *1 -24.9,-2.05
X$4 VDD \$3 in \$2 GND ota_5t_sky130
* cell instance $6 r0 *1 39.65,-10.15
X$6 VDD out \$3 out GND otaq_5t_sky130
* device instance $1 r90 *1 23.355,37.895 sky130_fd_pr__res_high_po_1p41
XR$1 \$3 GND GND sky130_fd_pr__res_high_po_1p41 R=20147.4 L=88830000 W=1410000
+ A=1.252503e+14 P=180480000
* device instance $2 r90 *1 23.405,41.665 sky130_fd_pr__res_high_po_1p41
XR$2 \$3 VDD GND sky130_fd_pr__res_high_po_1p41 R=20147.4 L=88830000 W=1410000
+ A=1.252503e+14 P=180480000
* device instance $3 r270 *1 18.47,-46.47 sky130_fd_pr__model__cap_mim
XC$3 GND \$2 sky130_fd_pr__model__cap_mim C=7.2 A=3.6e+15 P=480000000
* device instance $7 r270 *1 161.58,-47.25 sky130_fd_pr__model__cap_mim
XC$7 GND out sky130_fd_pr__model__cap_mim C=7.2 A=3.6e+15 P=480000000
.ENDS otaSys_5t_sky130

* cell ota_5t_sky130
* pin VDD
* pin VINP
* pin VINN
* pin VOUT
* pin GND
.SUBCKT ota_5t_sky130 VDD VINP VINN VOUT GND
* device instance $1 r90 *1 14.52,-7.01 sky130_fd_pr__nfet_01v8
XM$1 \$3 VINN VOUT GND sky130_fd_pr__nfet_01v8 L=500000 W=2000000
+ AS=580000000000 AD=580000000000 PS=4580000 PD=4580000
* device instance $2 r90 *1 6.43,-6.95 sky130_fd_pr__nfet_01v8
XM$2 \$3 VINP \$7 GND sky130_fd_pr__nfet_01v8 L=500000 W=2000000
+ AS=580000000000 AD=580000000000 PS=4580000 PD=4580000
* device instance $3 r90 *1 14.725,-3.27 sky130_fd_pr__pfet_01v8
XM$3 VOUT \$7 VDD VDD sky130_fd_pr__pfet_01v8 L=500000 W=5000000 AS=1.45e+12
+ AD=1.45e+12 PS=10580000 PD=10580000
* device instance $4 r90 *1 6.135,-3.28 sky130_fd_pr__pfet_01v8
XM$4 \$7 \$7 VDD VDD sky130_fd_pr__pfet_01v8 L=500000 W=5000000 AS=1.45e+12
+ AD=1.45e+12 PS=10580000 PD=10580000
* device instance $5 r90 *1 10.54,-12.18 sky130_fd_pr__nfet_01v8
XM$5 GND VDD \$3 GND sky130_fd_pr__nfet_01v8 L=1480000 W=4000000 AS=1.16e+12
+ AD=1.16e+12 PS=8580000 PD=8580000
* device instance $6 r90 *1 2.4,-12.1 sky130_fd_pr__nfet_01v8
XM$6 GND VDD VDD GND sky130_fd_pr__nfet_01v8 L=500000 W=4000000 AS=1.16e+12
+ AD=1.16e+12 PS=8580000 PD=8580000
.ENDS ota_5t_sky130

* cell otaq_5t_sky130
* pin VDD
* pin VINP
* pin VINN
* pin VOUT
* pin GND
.SUBCKT otaq_5t_sky130 VDD VINP VINN VOUT GND
* device instance $1 r90 *1 38.15,16.44 sky130_fd_pr__nfet_01v8
XM$1 \$3 VINN VOUT GND sky130_fd_pr__nfet_01v8 L=7000000 W=500000
+ AS=145000000000 AD=145000000000 PS=1580000 PD=1580000
* device instance $2 r90 *1 21.71,15.94 sky130_fd_pr__nfet_01v8
XM$2 \$3 VINP \$6 GND sky130_fd_pr__nfet_01v8 L=7000000 W=500000
+ AS=145000000000 AD=145000000000 PS=1580000 PD=1580000
* device instance $3 r90 *1 38.235,26.11 sky130_fd_pr__pfet_01v8
XM$3 VOUT \$6 VDD VDD sky130_fd_pr__pfet_01v8 L=7000000 W=1000000
+ AS=290000000000 AD=290000000000 PS=2580000 PD=2580000
* device instance $4 r90 *1 21.735,26.35 sky130_fd_pr__pfet_01v8
XM$4 \$6 \$6 VDD VDD sky130_fd_pr__pfet_01v8 L=7000000 W=1000000
+ AS=290000000000 AD=290000000000 PS=2580000 PD=2580000
* device instance $5 r90 *1 29.61,-0.97 sky130_fd_pr__nfet_01v8
XM$5 GND VDD \$3 GND sky130_fd_pr__nfet_01v8 L=20000000 W=500000
+ AS=145000000000 AD=145000000000 PS=1580000 PD=1580000
* device instance $6 r90 *1 19.33,-0.75 sky130_fd_pr__nfet_01v8
XM$6 GND VDD VDD GND sky130_fd_pr__nfet_01v8 L=500000 W=1000000 AS=290000000000
+ AD=290000000000 PS=2580000 PD=2580000
.ENDS otaq_5t_sky130
