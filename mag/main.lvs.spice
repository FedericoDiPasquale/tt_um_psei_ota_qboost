* NGSPICE file created from main.ext - technology: sky130A

.subckt sky130_fd_pr__nfet_01v8_8LGPJ7 B D S G
X0 S G D B sky130_fd_pr__nfet_01v8 ad=0.58 pd=4.58 as=0.58 ps=4.58 w=2 l=0.5
**devattr s=23200,916 d=23200,916
.ends

.subckt sky130_fd_pr__pfet_01v8_NMZPXD B D S G
X0 S G D B sky130_fd_pr__pfet_01v8 ad=1.45 pd=10.58 as=1.45 ps=10.58 w=5 l=0.5
**devattr s=58000,2116 d=58000,2116
.ends

.subckt sky130_fd_pr__nfet_01v8_6CY75A B D S G
X0 S G D B sky130_fd_pr__nfet_01v8 ad=1.16 pd=8.58 as=1.16 ps=8.58 w=4 l=1.48
**devattr s=46400,1716 d=46400,1716
.ends

.subckt sky130_fd_pr__nfet_01v8_EAQ5W9 B D S G
X0 S G D B sky130_fd_pr__nfet_01v8 ad=1.16 pd=8.58 as=1.16 ps=8.58 w=4 l=0.5
**devattr s=46400,1716 d=46400,1716
.ends

.subckt ota_5t_sky130 VDD VOUT VINP VINN GND
XXM1 GND XM5/S XM4/G VINP sky130_fd_pr__nfet_01v8_8LGPJ7
XXM2 GND XM5/S VOUT VINN sky130_fd_pr__nfet_01v8_8LGPJ7
XXM3 VDD XM4/G VDD XM4/G sky130_fd_pr__pfet_01v8_NMZPXD
XXM4 VDD VOUT VDD XM4/G sky130_fd_pr__pfet_01v8_NMZPXD
XXM5 GND GND XM5/S VDD sky130_fd_pr__nfet_01v8_6CY75A
XXM6 GND GND VDD VDD sky130_fd_pr__nfet_01v8_EAQ5W9
.ends

.subckt sky130_fd_pr__nfet_01v8_WMUBDE B D S G
X0 S G D B sky130_fd_pr__nfet_01v8 ad=0.145 pd=1.58 as=0.145 ps=1.58 w=0.5 l=7
**devattr s=5800,316 d=5800,316
.ends

.subckt sky130_fd_pr__pfet_01v8_5AEUQ7 B D S G
X0 S G D B sky130_fd_pr__pfet_01v8 ad=0.29 pd=2.58 as=0.29 ps=2.58 w=1 l=7
**devattr s=11600,516 d=11600,516
.ends

.subckt sky130_fd_pr__nfet_01v8_Y8ARZT B D S G
X0 S G D B sky130_fd_pr__nfet_01v8 ad=0.145 pd=1.58 as=0.145 ps=1.58 w=0.5 l=20
**devattr s=5800,316 d=5800,316
.ends

.subckt sky130_fd_pr__nfet_01v8_49D4KV B D S G
X0 S G D B sky130_fd_pr__nfet_01v8 ad=0.29 pd=2.58 as=0.29 ps=2.58 w=1 l=0.5
**devattr s=11600,516 d=11600,516
.ends

.subckt otaq_5t_sky130 VDD VOUT VINP VINN GND
XXM1 GND XM5/S XM4/G VINP sky130_fd_pr__nfet_01v8_WMUBDE
XXM2 GND XM5/S VOUT VINN sky130_fd_pr__nfet_01v8_WMUBDE
XXM3 VDD XM4/G VDD XM4/G sky130_fd_pr__pfet_01v8_5AEUQ7
XXM4 VDD VOUT VDD XM4/G sky130_fd_pr__pfet_01v8_5AEUQ7
XXM5 GND GND XM5/S VDD sky130_fd_pr__nfet_01v8_Y8ARZT
XXM6 GND GND VDD VDD sky130_fd_pr__nfet_01v8_49D4KV
.ends

.subckt sky130_fd_pr__res_high_po_1p41_2THKUN B R1 R2
X0 R1 R2 B sky130_fd_pr__res_high_po_1p41 l=88.83
.ends

.subckt sky130_fd_pr__cap_mim_m3_1_PPRVRG C2 C1
X0 C1 C2 sky130_fd_pr__cap_mim_m3_1 l=30 w=30
X1 C1 C2 sky130_fd_pr__cap_mim_m3_1 l=30 w=30
X2 C1 C2 sky130_fd_pr__cap_mim_m3_1 l=30 w=30
X3 C1 C2 sky130_fd_pr__cap_mim_m3_1 l=30 w=30
.ends

.subckt otaSys_5t_sky130 VDD in out GND
Xx1 VDD XC1/C1 x4/VINN in GND ota_5t_sky130
Xx2 VDD out XC1/C1 x4/VINN GND ota_5t_sky130
Xx3 VDD XC1/C1 x4/VINN out GND ota_5t_sky130
Xx4 VDD out out x4/VINN GND otaq_5t_sky130
Xsky130_fd_pr__res_high_po_1p41_2THKUN_0 GND VDD x4/VINN sky130_fd_pr__res_high_po_1p41_2THKUN
Xsky130_fd_pr__res_high_po_1p41_2THKUN_1 GND GND x4/VINN sky130_fd_pr__res_high_po_1p41_2THKUN
XXC1 GND XC1/C1 sky130_fd_pr__cap_mim_m3_1_PPRVRG
XXC2 GND out sky130_fd_pr__cap_mim_m3_1_PPRVRG
.ends

.subckt sky130_fd_pr__res_generic_po_2VQQNW B R1 R2
X0 R1 R2 sky130_fd_pr__res_generic_po w=1 l=21
.ends

.subckt sky130_fd_pr__res_generic_po_9W8GJE B R1 R2
X0 R1 R2 sky130_fd_pr__res_generic_po w=1 l=63
.ends

.subckt DAC3bit b0 b1 b2 VDD GND out
XXR1 GND XR2/R1 GND sky130_fd_pr__res_generic_po_2VQQNW
XXR10 GND XR9/R1 XR8/R2 sky130_fd_pr__res_generic_po_2VQQNW
XXR2 GND XR2/R1 XR9/R2 sky130_fd_pr__res_generic_po_2VQQNW
XXR11 GND out XR8/R2 sky130_fd_pr__res_generic_po_9W8GJE
XXR3 GND XR4/R2 b0 sky130_fd_pr__res_generic_po_2VQQNW
XXR12 GND VDD out sky130_fd_pr__res_generic_po_2VQQNW
XXR4 GND XR9/R2 XR4/R2 sky130_fd_pr__res_generic_po_2VQQNW
XXR5 GND b1 XR6/R1 sky130_fd_pr__res_generic_po_2VQQNW
XXR13 GND out GND sky130_fd_pr__res_generic_po_2VQQNW
XXR6 GND XR6/R1 XR9/R1 sky130_fd_pr__res_generic_po_2VQQNW
XXR7 GND b2 XR8/R1 sky130_fd_pr__res_generic_po_2VQQNW
XXR8 GND XR8/R1 XR8/R2 sky130_fd_pr__res_generic_po_2VQQNW
XXR9 GND XR9/R1 XR9/R2 sky130_fd_pr__res_generic_po_2VQQNW
.ends

.subckt main VDD GND b0 b1 b2 out
Xx1 VDD x1/in out GND otaSys_5t_sky130
Xx5 b0 b1 b2 VDD GND x1/in DAC3bit
.ends
