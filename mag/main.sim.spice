* NGSPICE file created from main_parax.ext - technology: sky130A

.subckt main_parax VDD GND b0 b1 b2 out
X0 x5.XR6.R1 x5.XR10.R1 sky130_fd_pr__res_generic_po w=1 l=21
X1 x5.XR10.R1 x5.XR11.R2 sky130_fd_pr__res_generic_po w=1 l=21
X2 VDD.t15 x1.x3.XM4.G x1.XC1.C1 VDD.t14 sky130_fd_pr__pfet_01v8 ad=1.45 pd=10.58 as=1.45 ps=10.58 w=5 l=0.5
X3 VDD.t11 VDD.t10 GND.t33 GND.t32 sky130_fd_pr__nfet_01v8 ad=1.16 pd=8.58 as=1.16 ps=8.58 w=4 l=0.5
X4 x1.XC1.C1 GND.t17 sky130_fd_pr__cap_mim_m3_1 l=30 w=30
X5 x1.x3.XM4.G x1.x4.VINN x1.x3.XM5.S GND.t3 sky130_fd_pr__nfet_01v8 ad=0.58 pd=4.58 as=0.58 ps=4.58 w=2 l=0.5
X6 out.t0 x1.x4.VINN x1.x4.XM5.S GND.t4 sky130_fd_pr__nfet_01v8 ad=0.145 pd=1.58 as=0.145 ps=1.58 w=0.5 l=7
X7 VDD.t7 VDD.t6 GND.t25 GND.t24 sky130_fd_pr__nfet_01v8 ad=0.29 pd=2.58 as=0.29 ps=2.58 w=1 l=0.5
X8 out.t6 GND.t11 sky130_fd_pr__cap_mim_m3_1 l=30 w=30
X9 x5.out GND.t14 sky130_fd_pr__res_generic_po w=1 l=21
X10 x1.x1.XM5.S VDD.t28 GND.t29 GND.t28 sky130_fd_pr__nfet_01v8 ad=1.16 pd=8.58 as=1.16 ps=8.58 w=4 l=1.48
X11 b2.t0 x5.XR8.R1 sky130_fd_pr__res_generic_po w=1 l=21
X12 x1.x2.XM5.S VDD.t27 GND.t35 GND.t34 sky130_fd_pr__nfet_01v8 ad=1.16 pd=8.58 as=1.16 ps=8.58 w=4 l=1.48
X13 x1.x4.XM4.G out.t8 x1.x4.XM5.S GND.t9 sky130_fd_pr__nfet_01v8 ad=0.145 pd=1.58 as=0.145 ps=1.58 w=0.5 l=7
X14 x1.XC1.C1 GND.t18 sky130_fd_pr__cap_mim_m3_1 l=30 w=30
X15 x1.x1.XM4.G x1.x4.VINN x1.x1.XM5.S GND.t5 sky130_fd_pr__nfet_01v8 ad=0.58 pd=4.58 as=0.58 ps=4.58 w=2 l=0.5
X16 x1.x4.XM5.S VDD.t26 GND.t31 GND.t30 sky130_fd_pr__nfet_01v8 ad=0.145 pd=1.58 as=0.145 ps=1.58 w=0.5 l=20
X17 VDD.t19 x1.x2.XM4.G x1.x2.XM4.G VDD.t18 sky130_fd_pr__pfet_01v8 ad=1.45 pd=10.58 as=1.45 ps=10.58 w=5 l=0.5
X18 VDD.t21 x1.x2.XM4.G out.t3 VDD.t20 sky130_fd_pr__pfet_01v8 ad=1.45 pd=10.58 as=1.45 ps=10.58 w=5 l=0.5
X19 x1.XC1.C1 GND.t19 sky130_fd_pr__cap_mim_m3_1 l=30 w=30
X20 VDD.t3 x1.x4.XM4.G out.t2 VDD.t2 sky130_fd_pr__pfet_01v8 ad=0.29 pd=2.58 as=0.29 ps=2.58 w=1 l=7
X21 x5.out x5.XR11.R2 sky130_fd_pr__res_generic_po w=1 l=63
X22 VDD.t9 VDD.t8 GND.t27 GND.t26 sky130_fd_pr__nfet_01v8 ad=1.16 pd=8.58 as=1.16 ps=8.58 w=4 l=0.5
X23 out.t7 GND.t10 sky130_fd_pr__cap_mim_m3_1 l=30 w=30
X24 out.t4 GND.t13 sky130_fd_pr__cap_mim_m3_1 l=30 w=30
X25 VDD.t13 VDD.t12 GND.t23 GND.t22 sky130_fd_pr__nfet_01v8 ad=1.16 pd=8.58 as=1.16 ps=8.58 w=4 l=0.5
X26 VDD.t5 x1.x4.XM4.G x1.x4.XM4.G VDD.t4 sky130_fd_pr__pfet_01v8 ad=0.29 pd=2.58 as=0.29 ps=2.58 w=1 l=7
X27 x5.XR4.R2 x5.XR9.R2 sky130_fd_pr__res_generic_po w=1 l=21
X28 x1.x3.XM5.S VDD.t29 GND.t21 GND.t20 sky130_fd_pr__nfet_01v8 ad=1.16 pd=8.58 as=1.16 ps=8.58 w=4 l=1.48
X29 x1.XC1.C1 x5.out x1.x1.XM5.S GND.t36 sky130_fd_pr__nfet_01v8 ad=0.58 pd=4.58 as=0.58 ps=4.58 w=2 l=0.5
X30 x5.XR2.R1 x5.XR9.R2 sky130_fd_pr__res_generic_po w=1 l=21
X31 b1.t0 x5.XR6.R1 sky130_fd_pr__res_generic_po w=1 l=21
X32 b0.t0 x5.XR4.R2 sky130_fd_pr__res_generic_po w=1 l=21
X33 out.t1 x1.x4.VINN x1.x2.XM5.S GND.t6 sky130_fd_pr__nfet_01v8 ad=0.58 pd=4.58 as=0.58 ps=4.58 w=2 l=0.5
X34 VDD.t0 x1.x4.VINN GND.t7 sky130_fd_pr__res_high_po_1p41 l=88.83
X35 out.t5 GND.t12 sky130_fd_pr__cap_mim_m3_1 l=30 w=30
X36 x1.XC1.C1 out.t9 x1.x3.XM5.S GND.t8 sky130_fd_pr__nfet_01v8 ad=0.58 pd=4.58 as=0.58 ps=4.58 w=2 l=0.5
X37 GND.t0 x5.XR2.R1 sky130_fd_pr__res_generic_po w=1 l=21
X38 x5.XR9.R2 x5.XR10.R1 sky130_fd_pr__res_generic_po w=1 l=21
X39 x1.XC1.C1 GND.t16 sky130_fd_pr__cap_mim_m3_1 l=30 w=30
X40 VDD.t1 x5.out sky130_fd_pr__res_generic_po w=1 l=21
X41 GND.t2 x1.x4.VINN GND.t1 sky130_fd_pr__res_high_po_1p41 l=88.83
X42 VDD.t17 x1.x3.XM4.G x1.x3.XM4.G VDD.t16 sky130_fd_pr__pfet_01v8 ad=1.45 pd=10.58 as=1.45 ps=10.58 w=5 l=0.5
X43 VDD.t25 x1.x1.XM4.G x1.x1.XM4.G VDD.t24 sky130_fd_pr__pfet_01v8 ad=1.45 pd=10.58 as=1.45 ps=10.58 w=5 l=0.5
X44 VDD.t23 x1.x1.XM4.G x1.XC1.C1 VDD.t22 sky130_fd_pr__pfet_01v8 ad=1.45 pd=10.58 as=1.45 ps=10.58 w=5 l=0.5
X45 x5.XR8.R1 x5.XR11.R2 sky130_fd_pr__res_generic_po w=1 l=21
X46 x1.x2.XM4.G x1.XC1.C1 x1.x2.XM5.S GND.t15 sky130_fd_pr__nfet_01v8 ad=0.58 pd=4.58 as=0.58 ps=4.58 w=2 l=0.5
R0 out out.t9 285.474
R1 out.t9 out 274.911
R2 out out.t2 223.565
R3 out out.t0 219.8
R4 out out.t3 47.4992
R5 out out.t1 39.5338
R6 out.n5 out.n4 22.2846
R7 out.n3 out 19.8925
R8 out.n0 out 14.1405
R9 out.n1 out 13.5479
R10 out out.n5 11.6717
R11 out.n4 out 11.2789
R12 out out.t8 11.2155
R13 out.n0 out 9.52394
R14 out.n2 out 6.77178
R15 out out.n0 5.92238
R16 out out.n2 5.82436
R17 out.n1 out 5.67664
R18 out.n2 out 5.58145
R19 out.n4 out.n3 4.5005
R20 out.n5 out.n1 3.86414
R21 out.n3 out 0.813
R22 out.n6 out.t7 0.264341
R23 out.n7 out.n6 0.263519
R24 out out.n7 0.263519
R25 out.n6 out.t6 0.00132177
R26 out.n7 out.t5 0.00132177
R27 out out.t4 0.00132177
R28 b2 b2.t0 171.678
R29 b1 b1.t0 171.678
R30 b0 b0.t0 171.678
R31 VDD.n21 VDD.n16 3854.12
R32 VDD.n19 VDD.n18 3854.12
R33 VDD.n8 VDD.n7 3854.12
R34 VDD.n5 VDD.n3 3854.12
R35 VDD.n104 VDD.n99 2971.76
R36 VDD.n102 VDD.n101 2971.76
R37 VDD.n91 VDD.n85 2971.76
R38 VDD.n88 VDD.n86 2971.76
R39 VDD.n76 VDD.n71 2971.76
R40 VDD.n74 VDD.n73 2971.76
R41 VDD.n63 VDD.n57 2971.76
R42 VDD.n60 VDD.n58 2971.76
R43 VDD.n50 VDD.n44 2971.76
R44 VDD.n48 VDD.n47 2971.76
R45 VDD.n37 VDD.n31 2971.76
R46 VDD.n34 VDD.n32 2971.76
R47 VDD.n101 VDD.n100 924.852
R48 VDD.n104 VDD.n103 924.852
R49 VDD.n89 VDD.n85 924.852
R50 VDD.n90 VDD.n86 924.852
R51 VDD.n73 VDD.n72 924.852
R52 VDD.n76 VDD.n75 924.852
R53 VDD.n61 VDD.n57 924.852
R54 VDD.n62 VDD.n58 924.852
R55 VDD.n47 VDD.n46 924.852
R56 VDD.n50 VDD.n49 924.852
R57 VDD.n35 VDD.n31 924.852
R58 VDD.n36 VDD.n32 924.852
R59 VDD.n22 VDD.n15 411.106
R60 VDD VDD.n15 411.106
R61 VDD.n4 VDD.n1 411.106
R62 VDD.n4 VDD 411.106
R63 VDD VDD.n14 409.243
R64 VDD.n23 VDD.n22 406.212
R65 VDD.n9 VDD.n1 404.981
R66 VDD.n10 VDD 403.462
R67 VDD.n95 VDD.t8 381.204
R68 VDD.n67 VDD.t10 381.204
R69 VDD.n28 VDD.t12 381.204
R70 VDD.t8 VDD 371.31
R71 VDD.t10 VDD 371.31
R72 VDD.t12 VDD 371.31
R73 VDD.n105 VDD.n98 316.988
R74 VDD VDD.n98 316.988
R75 VDD VDD.n97 316.988
R76 VDD.n92 VDD.n84 316.988
R77 VDD.n87 VDD.n84 316.988
R78 VDD.n87 VDD 316.988
R79 VDD.n77 VDD.n70 316.988
R80 VDD VDD.n70 316.988
R81 VDD VDD.n69 316.988
R82 VDD.n64 VDD.n56 316.988
R83 VDD.n59 VDD.n56 316.988
R84 VDD.n59 VDD 316.988
R85 VDD VDD.n43 316.988
R86 VDD.n45 VDD.n43 316.988
R87 VDD.n45 VDD.n42 316.988
R88 VDD.n38 VDD 316.988
R89 VDD.n33 VDD 316.988
R90 VDD.n33 VDD.n30 316.988
R91 VDD.n93 VDD 286.495
R92 VDD.n65 VDD 286.495
R93 VDD.n51 VDD 286.495
R94 VDD.n106 VDD.n105 282.084
R95 VDD.n78 VDD.n77 282.084
R96 VDD.n39 VDD.n30 282.084
R97 VDD.n12 VDD.t6 237.002
R98 VDD.t6 VDD 226.71
R99 VDD VDD.t5 223.565
R100 VDD VDD.t3 223.565
R101 VDD VDD.t1 171.678
R102 VDD.n18 VDD.n17 142.75
R103 VDD.n21 VDD.n20 142.75
R104 VDD.n3 VDD.n2 142.75
R105 VDD.n7 VDD.n6 142.75
R106 VDD VDD.t28 112.091
R107 VDD VDD.t27 112.091
R108 VDD VDD.t29 112.091
R109 VDD VDD.t7 79.0672
R110 VDD.n105 VDD.n104 61.6672
R111 VDD.n101 VDD 61.6672
R112 VDD.n85 VDD.n84 61.6672
R113 VDD.n86 VDD 61.6672
R114 VDD.n77 VDD.n76 61.6672
R115 VDD.n73 VDD 61.6672
R116 VDD.n57 VDD.n56 61.6672
R117 VDD.n58 VDD 61.6672
R118 VDD VDD.n50 61.6672
R119 VDD.n47 VDD.n45 61.6672
R120 VDD.n31 VDD 61.6672
R121 VDD.n32 VDD.n30 61.6672
R122 VDD VDD.t25 47.4992
R123 VDD VDD.t23 47.4992
R124 VDD VDD.t19 47.4992
R125 VDD VDD.t21 47.4992
R126 VDD VDD.t15 47.4992
R127 VDD VDD.t17 47.4992
R128 VDD.n19 VDD.n15 30.8338
R129 VDD.n16 VDD.n14 30.8338
R130 VDD.n5 VDD.n4 30.8338
R131 VDD.n9 VDD.n8 30.8338
R132 VDD.n17 VDD.n16 29.4567
R133 VDD.n20 VDD.n19 29.4567
R134 VDD.n8 VDD.n2 29.4567
R135 VDD.n6 VDD.n5 29.4567
R136 VDD.n83 VDD.n82 26.1321
R137 VDD VDD.t9 21.1687
R138 VDD VDD.t11 21.1687
R139 VDD VDD.t13 21.1687
R140 VDD.n93 VDD.n92 18.4476
R141 VDD.n65 VDD.n64 18.4476
R142 VDD.n51 VDD.n42 18.4476
R143 VDD VDD.n114 16.0646
R144 VDD.n106 VDD.n97 15.5434
R145 VDD.n78 VDD.n69 15.5434
R146 VDD.n39 VDD.n38 15.5434
R147 VDD.n96 VDD.n95 15.4443
R148 VDD.n68 VDD.n67 15.4443
R149 VDD.n29 VDD.n28 15.4443
R150 VDD.n55 VDD.n27 15.4198
R151 VDD.n13 VDD.n12 15.217
R152 VDD.n25 VDD.n13 14.6786
R153 VDD.n24 VDD.n23 13.8005
R154 VDD.n112 VDD.n111 13.33
R155 VDD.n111 VDD.n110 12.223
R156 VDD.n107 VDD.n106 11.5505
R157 VDD.n94 VDD.n93 11.5505
R158 VDD.n79 VDD.n78 11.5505
R159 VDD.n66 VDD.n65 11.5505
R160 VDD.n52 VDD.n51 11.5505
R161 VDD.n40 VDD.n39 11.5505
R162 VDD.n11 VDD.n10 11.5505
R163 VDD.n102 VDD.n98 10.8829
R164 VDD.n99 VDD.n97 10.8829
R165 VDD.n92 VDD.n91 10.8829
R166 VDD.n88 VDD.n87 10.8829
R167 VDD.n74 VDD.n70 10.8829
R168 VDD.n71 VDD.n69 10.8829
R169 VDD.n64 VDD.n63 10.8829
R170 VDD.n60 VDD.n59 10.8829
R171 VDD.n48 VDD.n43 10.8829
R172 VDD.n44 VDD.n42 10.8829
R173 VDD.n38 VDD.n37 10.8829
R174 VDD.n34 VDD.n33 10.8829
R175 VDD.n0 VDD.t0 10.1864
R176 VDD.n24 VDD 9.29564
R177 VDD.n11 VDD 9.29224
R178 VDD.n22 VDD.n21 8.40959
R179 VDD.n18 VDD 8.40959
R180 VDD.n7 VDD.n1 8.40959
R181 VDD.n3 VDD 8.40959
R182 VDD.n0 VDD 8.2161
R183 VDD.n108 VDD.n96 7.70242
R184 VDD.n80 VDD.n68 7.70242
R185 VDD.n41 VDD.n29 7.70242
R186 VDD.n26 VDD.n11 7.50943
R187 VDD.n100 VDD.n99 7.46928
R188 VDD.n103 VDD.n102 7.46928
R189 VDD.n72 VDD.n71 7.46928
R190 VDD.n75 VDD.n74 7.46928
R191 VDD.n46 VDD.n44 7.46928
R192 VDD.n49 VDD.n48 7.46928
R193 VDD.n91 VDD.n90 7.46927
R194 VDD.n89 VDD.n88 7.46927
R195 VDD.n63 VDD.n62 7.46927
R196 VDD.n61 VDD.n60 7.46927
R197 VDD.n37 VDD.n36 7.46927
R198 VDD.n35 VDD.n34 7.46927
R199 VDD.n114 VDD 7.35149
R200 VDD.n13 VDD 6.60988
R201 VDD.n96 VDD 6.37373
R202 VDD.n68 VDD 6.37373
R203 VDD.n29 VDD 6.37373
R204 VDD.n55 VDD.n54 6.15478
R205 VDD.n113 VDD 6.05832
R206 VDD.n111 VDD.n83 5.71641
R207 VDD.n27 VDD.n26 4.98488
R208 VDD.n25 VDD.n24 4.87029
R209 VDD.n83 VDD.n55 4.56868
R210 VDD.n110 VDD 4.56613
R211 VDD.n82 VDD 4.56613
R212 VDD.n27 VDD 4.563
R213 VDD.n54 VDD 4.53488
R214 VDD VDD.t26 3.88644
R215 VDD.n109 VDD.n94 3.50493
R216 VDD.n81 VDD.n66 3.50493
R217 VDD.n53 VDD.n52 3.50493
R218 VDD.n103 VDD.t24 3.38773
R219 VDD.n100 VDD.t24 3.38773
R220 VDD.n75 VDD.t18 3.38773
R221 VDD.n72 VDD.t18 3.38773
R222 VDD.n49 VDD.t14 3.38773
R223 VDD.n46 VDD.t14 3.38773
R224 VDD.n90 VDD.t22 3.38773
R225 VDD.t22 VDD.n89 3.38773
R226 VDD.n62 VDD.t20 3.38773
R227 VDD.t20 VDD.n61 3.38773
R228 VDD.n36 VDD.t16 3.38773
R229 VDD.t16 VDD.n35 3.38773
R230 VDD.n94 VDD 3.13354
R231 VDD.n66 VDD 3.13354
R232 VDD.n52 VDD 3.13354
R233 VDD.n107 VDD 3.12662
R234 VDD.n79 VDD 3.12662
R235 VDD.n40 VDD 3.12662
R236 VDD.n95 VDD 2.60425
R237 VDD.n67 VDD 2.60425
R238 VDD.n28 VDD 2.60425
R239 VDD.n110 VDD.n109 2.60146
R240 VDD.n82 VDD.n81 2.60146
R241 VDD.n54 VDD.n53 2.60146
R242 VDD.n26 VDD.n25 2.54738
R243 VDD.n108 VDD.n107 2.48264
R244 VDD.n80 VDD.n79 2.48264
R245 VDD.n41 VDD.n40 2.48264
R246 VDD.n23 VDD.n14 2.2405
R247 VDD.n12 VDD 1.64459
R248 VDD.n20 VDD.t4 1.143
R249 VDD.n17 VDD.t4 1.143
R250 VDD.n6 VDD.t2 1.143
R251 VDD.t2 VDD.n2 1.143
R252 VDD.n114 VDD.n113 1.1255
R253 VDD.n109 VDD.n108 1.02279
R254 VDD.n81 VDD.n80 1.02279
R255 VDD.n53 VDD.n41 1.02279
R256 VDD.n112 VDD.n0 0.855594
R257 VDD.n10 VDD.n9 0.738962
R258 VDD VDD.n112 0.358455
R259 VDD.n113 VDD 0.066125
R260 GND.n358 GND.n66 3.29681e+07
R261 GND.n163 GND.n162 1.31417e+07
R262 GND.n358 GND.n357 1.8899e+06
R263 GND.n99 GND.n66 1.8898e+06
R264 GND.n164 GND.n163 1.8898e+06
R265 GND.n169 GND.n165 154930
R266 GND.n176 GND.n165 140199
R267 GND.n234 GND.t1 56449
R268 GND.n149 GND.n82 55907.4
R269 GND.n316 GND.n82 55907.4
R270 GND.n149 GND.n83 55907.4
R271 GND.n316 GND.n83 55907.4
R272 GND.n159 GND.n153 55907.4
R273 GND.n159 GND.n154 55907.4
R274 GND.n153 GND.n152 55907.4
R275 GND.n154 GND.n152 55907.4
R276 GND.n75 GND.n4 40784.8
R277 GND.n396 GND.n4 40784.8
R278 GND.n75 GND.n5 40784.8
R279 GND.n396 GND.n5 40784.8
R280 GND.n164 GND.n148 36641.5
R281 GND.n165 GND.n164 27694.8
R282 GND.n235 GND.n99 24146.7
R283 GND.n235 GND.n234 19923.7
R284 GND.n345 GND.n341 16449.5
R285 GND.n345 GND.n342 16449.5
R286 GND.n348 GND.n341 16449.5
R287 GND.n355 GND.n337 16449.5
R288 GND.n355 GND.n338 16449.5
R289 GND.n337 GND.n335 16449.5
R290 GND.n338 GND.n335 16449.5
R291 GND.n370 GND.n27 16449.5
R292 GND.n372 GND.n27 16449.5
R293 GND.n371 GND.n370 16449.5
R294 GND.n372 GND.n371 16449.5
R295 GND.n41 GND.n36 16449.5
R296 GND.n41 GND.n37 16449.5
R297 GND.n36 GND.n35 16449.5
R298 GND.n37 GND.n35 16449.5
R299 GND.n365 GND.n19 16449.5
R300 GND.n380 GND.n19 16449.5
R301 GND.n365 GND.n20 16449.5
R302 GND.n380 GND.n20 16449.5
R303 GND.n64 GND.n57 16449.5
R304 GND.n64 GND.n60 16449.5
R305 GND.n57 GND.n34 16449.5
R306 GND.n60 GND.n34 16449.5
R307 GND.n383 GND.n15 16449.5
R308 GND.n383 GND.n16 16449.5
R309 GND.n385 GND.n15 16449.5
R310 GND.n385 GND.n16 16449.5
R311 GND.n360 GND.n30 16449.5
R312 GND.n363 GND.n30 16449.5
R313 GND.n360 GND.n31 16449.5
R314 GND.n363 GND.n31 16449.5
R315 GND.n49 GND.n45 16449.5
R316 GND.n54 GND.n45 16449.5
R317 GND.n49 GND.n48 16449.5
R318 GND.n54 GND.n48 16449.5
R319 GND.n393 GND.n8 16449.5
R320 GND.n43 GND.n8 16449.5
R321 GND.n393 GND.n9 16449.5
R322 GND.n43 GND.n9 16449.5
R323 GND.n320 GND.n78 16449.5
R324 GND.n324 GND.n78 16449.5
R325 GND.n320 GND.n79 16449.5
R326 GND.n324 GND.n79 16449.5
R327 GND.n327 GND.n68 16449.5
R328 GND.n327 GND.n69 16449.5
R329 GND.n330 GND.n68 16449.5
R330 GND.n330 GND.n69 16449.5
R331 GND.n189 GND.n123 13517.7
R332 GND.n189 GND.n124 13517.7
R333 GND.n190 GND.n123 13517.7
R334 GND.n190 GND.n124 13517.7
R335 GND.n213 GND.n212 7703.29
R336 GND.n170 GND.n166 5985.32
R337 GND.n173 GND.n166 5985.32
R338 GND.n170 GND.n167 5985.32
R339 GND.n173 GND.n167 5985.32
R340 GND.n185 GND.n177 5985.32
R341 GND.n182 GND.n177 5985.32
R342 GND.n185 GND.n178 5985.32
R343 GND.n182 GND.n178 5985.32
R344 GND.n161 GND.n106 4814.91
R345 GND.n161 GND.n107 4814.91
R346 GND.n219 GND.n107 4814.91
R347 GND.n219 GND.n106 4814.91
R348 GND.n269 GND.n267 4814.91
R349 GND.n301 GND.n267 4814.91
R350 GND.n269 GND.n268 4814.91
R351 GND.n301 GND.n268 4814.91
R352 GND.n110 GND.n93 4814.91
R353 GND.n255 GND.n93 4814.91
R354 GND.n110 GND.n94 4814.91
R355 GND.n255 GND.n94 4814.91
R356 GND.n292 GND.n285 4247.09
R357 GND.n292 GND.n286 4247.09
R358 GND.n285 GND.n284 4247.09
R359 GND.n286 GND.n284 4247.09
R360 GND.n245 GND.n238 4247.09
R361 GND.n245 GND.n239 4247.09
R362 GND.n239 GND.n237 4247.09
R363 GND.n238 GND.n237 4247.09
R364 GND.n134 GND.n130 4247.09
R365 GND.n134 GND.n131 4247.09
R366 GND.n139 GND.n130 4247.09
R367 GND.n139 GND.n131 4247.09
R368 GND.n246 GND.n235 3674.71
R369 GND.n158 GND.n157 3632.56
R370 GND.n158 GND 3632.56
R371 GND.n155 GND 3632.56
R372 GND.n315 GND.n84 3632.56
R373 GND GND.n84 3632.56
R374 GND GND.n85 3632.56
R375 GND.n156 GND.n155 3375.28
R376 GND.n314 GND.n85 3375.28
R377 GND.n206 GND.n112 3088.26
R378 GND.n210 GND.n112 3088.26
R379 GND.n206 GND.n113 3088.26
R380 GND.n210 GND.n113 3088.26
R381 GND.n215 GND.n100 3088.26
R382 GND.n232 GND.n100 3088.26
R383 GND.n215 GND.n101 3088.26
R384 GND.n232 GND.n101 3088.26
R385 GND.n147 GND.n126 3088.26
R386 GND.n143 GND.n126 3088.26
R387 GND.n147 GND.n127 3088.26
R388 GND.n143 GND.n127 3088.26
R389 GND.n299 GND.n283 3088.26
R390 GND.n299 GND.n294 3088.26
R391 GND.n283 GND.n282 3088.26
R392 GND.n294 GND.n282 3088.26
R393 GND.n253 GND.n98 3088.26
R394 GND.n253 GND.n248 3088.26
R395 GND.n98 GND.n97 3088.26
R396 GND.n248 GND.n97 3088.26
R397 GND.n274 GND.n271 3088.26
R398 GND.n274 GND.n272 3088.26
R399 GND.n278 GND.n271 3088.26
R400 GND.n278 GND.n272 3088.26
R401 GND.n397 GND.n3 2649.98
R402 GND.n74 GND.n3 2649.98
R403 GND.n74 GND 2630.63
R404 GND.n398 GND.n397 2628.39
R405 GND.n163 GND.t7 2604.15
R406 GND.n162 GND.t20 2571.08
R407 GND.n202 GND.n116 2508.85
R408 GND.n202 GND.n117 2508.85
R409 GND.n118 GND.n117 2508.85
R410 GND.n118 GND.n116 2508.85
R411 GND.n219 GND.n218 1994.52
R412 GND.n203 GND.n115 1958.16
R413 GND.n99 GND.n81 1501.21
R414 GND.n323 GND.n80 1068.8
R415 GND.n321 GND.n80 1068.8
R416 GND GND.n321 1068.8
R417 GND.n349 GND.n340 1068.8
R418 GND.n344 GND.n340 1068.8
R419 GND.n344 GND 1068.8
R420 GND.n354 GND.n353 1068.8
R421 GND.n354 GND 1068.8
R422 GND.n339 GND 1068.8
R423 GND.n392 GND.n10 1068.8
R424 GND.n392 GND 1068.8
R425 GND.n386 GND.n14 1068.8
R426 GND.n382 GND.n14 1068.8
R427 GND.n382 GND 1068.8
R428 GND.n362 GND.n361 1068.8
R429 GND.n361 GND 1068.8
R430 GND GND.n32 1068.8
R431 GND.n50 GND 1068.8
R432 GND.n51 GND.n50 1068.8
R433 GND GND.n379 1068.8
R434 GND GND.n21 1068.8
R435 GND.n22 GND.n21 1068.8
R436 GND.n63 GND 1068.8
R437 GND.n63 GND.n62 1068.8
R438 GND.n62 GND.n61 1068.8
R439 GND GND.n26 1068.8
R440 GND.n28 GND.n26 1068.8
R441 GND.n28 GND.n25 1068.8
R442 GND.n40 GND.n39 1068.8
R443 GND.n40 GND 1068.8
R444 GND GND.n38 1068.8
R445 GND.n328 GND.n72 1068.8
R446 GND.n329 GND.n328 1068.8
R447 GND.n11 GND.n10 1067.74
R448 GND.n53 GND 1057.72
R449 GND.n133 GND.n129 1056.41
R450 GND.n52 GND.n51 1053.74
R451 GND.n332 GND.n331 1044.71
R452 GND GND.n329 1043.69
R453 GND.n72 GND.n71 1041.32
R454 GND.n129 GND.n115 1019.86
R455 GND GND.n391 1015.76
R456 GND.n236 GND.n66 971.202
R457 GND.n205 GND.n204 952.756
R458 GND.n347 GND.n342 947.501
R459 GND.n331 GND.n67 914.933
R460 GND.n387 GND.n386 893.741
R461 GND.n188 GND.n122 878.307
R462 GND.n188 GND 878.307
R463 GND.n350 GND.n349 877.616
R464 GND.n191 GND.n122 874.712
R465 GND.n192 GND 873.327
R466 GND.n356 GND.n336 859.639
R467 GND.n346 GND.n343 859.639
R468 GND.n61 GND.n23 843.672
R469 GND.n379 GND.n378 842.165
R470 GND.n38 GND.n24 832.269
R471 GND.n352 GND.n339 828.552
R472 GND.n373 GND.n25 828.111
R473 GND.n32 GND.n13 821.082
R474 GND.n151 GND.n99 787.807
R475 GND.n148 GND.n125 784.577
R476 GND.n357 GND.n334 766.617
R477 GND.n273 GND.n66 733.768
R478 GND.n319 GND.n317 710.058
R479 GND.n77 GND.n76 682.615
R480 GND.n163 GND.n150 674.403
R481 GND.n59 GND.n58 630.428
R482 GND.n368 GND.n367 613.275
R483 GND.n384 GND.n381 613.275
R484 GND.n322 GND 567.04
R485 GND.n323 GND.n322 412.312
R486 GND GND.n184 388.894
R487 GND.n184 GND.n183 388.894
R488 GND.n183 GND.n179 388.894
R489 GND.n172 GND.n171 388.894
R490 GND.n171 GND 388.894
R491 GND GND.n168 388.894
R492 GND.n333 GND.n332 385.099
R493 GND.n359 GND.n358 360.664
R494 GND.n175 GND.n174 331.401
R495 GND.n160 GND.n105 312.848
R496 GND.n160 GND 312.848
R497 GND.n220 GND 312.848
R498 GND.n302 GND.n266 312.848
R499 GND GND.n266 312.848
R500 GND GND.n265 312.848
R501 GND.n256 GND.n92 312.848
R502 GND GND.n92 312.848
R503 GND GND.n91 312.848
R504 GND.n234 GND.n233 312.183
R505 GND.n187 GND.n186 298.558
R506 GND.n233 GND.t8 276.55
R507 GND.n291 GND 275.954
R508 GND.n291 GND.n290 275.954
R509 GND.n287 GND 275.954
R510 GND.n244 GND 275.954
R511 GND.n244 GND.n243 275.954
R512 GND.n240 GND 275.954
R513 GND GND.n138 275.954
R514 GND GND.n132 275.954
R515 GND.n135 GND.n132 275.954
R516 GND.n117 GND.n114 269.86
R517 GND.n358 GND.n65 269.764
R518 GND.n343 GND.n336 258.901
R519 GND.n142 GND.n108 234.885
R520 GND.n334 GND.n333 221.496
R521 GND GND.t31 219.8
R522 GND.n362 GND.n13 218.353
R523 GND.n221 GND.n105 216.066
R524 GND.n303 GND.n302 216.066
R525 GND.n257 GND.n256 216.066
R526 GND.n353 GND.n352 206.245
R527 GND.n141 GND.t3 205.427
R528 GND.n172 GND.n121 204.518
R529 GND.n214 GND.n102 200.66
R530 GND GND.n102 200.66
R531 GND.n214 GND.n103 200.66
R532 GND.n146 GND.n128 200.66
R533 GND GND.n128 200.66
R534 GND.n144 GND 200.66
R535 GND.n298 GND.n297 200.66
R536 GND.n298 GND 200.66
R537 GND.n295 GND 200.66
R538 GND.n252 GND.n251 200.66
R539 GND.n252 GND 200.66
R540 GND.n249 GND 200.66
R541 GND.n209 GND.n208 200.66
R542 GND.n209 GND.n207 200.66
R543 GND.n207 GND 200.66
R544 GND.n277 GND.n276 200.66
R545 GND.n277 GND.n275 200.66
R546 GND.n275 GND 200.66
R547 GND.n179 GND.n120 198.589
R548 GND.n218 GND.n217 197.685
R549 GND GND.n143 195
R550 GND.n143 GND.n142 195
R551 GND GND.n238 195
R552 GND.n238 GND.n96 195
R553 GND.n251 GND.n248 195
R554 GND.n248 GND.n247 195
R555 GND GND.n98 195
R556 GND.n98 GND.n95 195
R557 GND.n243 GND.n239 195
R558 GND.n239 GND.n236 195
R559 GND.n290 GND.n286 195
R560 GND.n286 GND.n67 195
R561 GND GND.n285 195
R562 GND.n285 GND.n281 195
R563 GND.n297 GND.n294 195
R564 GND.n294 GND.n293 195
R565 GND GND.n283 195
R566 GND.n283 GND.n280 195
R567 GND.n278 GND.n277 195
R568 GND.n279 GND.n278 195
R569 GND GND.n274 195
R570 GND.n274 GND.n273 195
R571 GND GND.n116 195
R572 GND.n180 GND.n116 195
R573 GND.n232 GND 195
R574 GND.n233 GND.n232 195
R575 GND.n215 GND.n214 195
R576 GND.n216 GND.n215 195
R577 GND.n210 GND.n209 195
R578 GND.n211 GND.n210 195
R579 GND GND.n206 195
R580 GND.n206 GND.n205 195
R581 GND.n200 GND.n117 195
R582 GND.n147 GND.n146 195
R583 GND.n148 GND.n147 195
R584 GND.n139 GND 195
R585 GND.n140 GND.n139 195
R586 GND.n135 GND.n134 195
R587 GND.n134 GND.t22 195
R588 GND.t3 GND.n140 193.024
R589 GND.n39 GND.n24 188.129
R590 GND.n378 GND.n22 185.976
R591 GND.n395 GND.n394 185.722
R592 GND.n109 GND.t8 185.142
R593 GND GND.n23 184.471
R594 GND.n290 GND.n289 183.417
R595 GND.n243 GND.n242 183.417
R596 GND.n137 GND.n135 183.417
R597 GND.t32 GND.n236 181.166
R598 GND.t26 GND.n67 181.166
R599 GND.t22 GND.n125 180.912
R600 GND.t22 GND.n133 180.912
R601 GND.n168 GND.n121 177.036
R602 GND.n18 GND.n16 176.143
R603 GND GND.t14 171.678
R604 GND GND.t0 171.678
R605 GND GND.n120 165.835
R606 GND.n201 GND 163.012
R607 GND.n201 GND.n200 163.012
R608 GND.n157 GND.n156 162.862
R609 GND.n315 GND.n314 162.862
R610 GND.n366 GND.n364 161.712
R611 GND.n350 GND 153.663
R612 GND.t34 GND.n211 152.095
R613 GND.n119 GND 151.299
R614 GND.n280 GND.t28 151.243
R615 GND.n200 GND.n199 150.784
R616 GND.n373 GND 149.333
R617 GND.n328 GND.n327 146.25
R618 GND.n327 GND.n326 146.25
R619 GND GND.n79 146.25
R620 GND.n79 GND.n73 146.25
R621 GND.n80 GND.n78 146.25
R622 GND.n78 GND.n73 146.25
R623 GND.n10 GND.n8 146.25
R624 GND.n46 GND.n8 146.25
R625 GND.n363 GND.n362 146.25
R626 GND.n364 GND.n363 146.25
R627 GND GND.n360 146.25
R628 GND.n360 GND.n359 146.25
R629 GND.n16 GND.n14 146.25
R630 GND.n15 GND 146.25
R631 GND.n368 GND.n15 146.25
R632 GND.n4 GND.n3 146.25
R633 GND.n6 GND.n4 146.25
R634 GND.n51 GND.n48 146.25
R635 GND.n48 GND.n47 146.25
R636 GND GND.n45 146.25
R637 GND.n47 GND.n45 146.25
R638 GND GND.n60 146.25
R639 GND.n60 GND.n59 146.25
R640 GND.n62 GND.n57 146.25
R641 GND.n57 GND.n56 146.25
R642 GND.n380 GND 146.25
R643 GND.n381 GND.n380 146.25
R644 GND.n365 GND.n22 146.25
R645 GND.n366 GND.n365 146.25
R646 GND.n39 GND.n37 146.25
R647 GND.n37 GND.n29 146.25
R648 GND GND.n36 146.25
R649 GND.n36 GND.n33 146.25
R650 GND GND.n372 146.25
R651 GND.n372 GND.n18 146.25
R652 GND.n370 GND.n28 146.25
R653 GND.n370 GND.n369 146.25
R654 GND.n330 GND 146.25
R655 GND.n331 GND.n330 146.25
R656 GND.n353 GND.n338 146.25
R657 GND.n338 GND.n336 146.25
R658 GND GND.n337 146.25
R659 GND.n337 GND.n334 146.25
R660 GND.n342 GND.n340 146.25
R661 GND.n341 GND 146.25
R662 GND.n343 GND.n341 146.25
R663 GND GND.n9 146.25
R664 GND.n333 GND.n9 146.25
R665 GND.n5 GND 146.25
R666 GND.n332 GND.n5 146.25
R667 GND.n191 GND.n190 146.25
R668 GND.n190 GND.t30 146.25
R669 GND.n189 GND.n188 146.25
R670 GND.t30 GND.n189 146.25
R671 GND.n179 GND.n178 146.25
R672 GND.n178 GND.t9 146.25
R673 GND.n184 GND.n177 146.25
R674 GND.n177 GND.t9 146.25
R675 GND.n168 GND.n167 146.25
R676 GND.n167 GND.t4 146.25
R677 GND.n171 GND.n166 146.25
R678 GND.n166 GND.t4 146.25
R679 GND.n293 GND.t26 146.038
R680 GND.n247 GND.n246 145.881
R681 GND.n204 GND.n203 143.417
R682 GND.t28 GND.n279 142.786
R683 GND.n387 GND 135.906
R684 GND.n212 GND.n95 129.248
R685 GND.n108 GND.t20 125.582
R686 GND GND.n231 124.047
R687 GND GND.n89 124.047
R688 GND GND.n263 124.047
R689 GND.n205 GND.t6 123.686
R690 GND.n146 GND.n145 120.922
R691 GND.n297 GND.n296 120.922
R692 GND.n251 GND.n250 120.922
R693 GND.n153 GND.n150 120.487
R694 GND.n157 GND.n154 117.001
R695 GND.n154 GND.n81 117.001
R696 GND.n316 GND.n315 117.001
R697 GND.n317 GND.n316 117.001
R698 GND.n149 GND 117.001
R699 GND.n150 GND.n149 117.001
R700 GND GND.n153 117.001
R701 GND.n119 GND.n118 117.001
R702 GND.n118 GND.t24 117.001
R703 GND.n202 GND.n201 117.001
R704 GND.n203 GND.n202 117.001
R705 GND.n273 GND.t36 116.115
R706 GND.n106 GND.n105 97.5005
R707 GND.n141 GND.n106 97.5005
R708 GND.n256 GND.n255 97.5005
R709 GND.n255 GND.n254 97.5005
R710 GND.n302 GND.n301 97.5005
R711 GND.n301 GND.n300 97.5005
R712 GND.n269 GND 97.5005
R713 GND.n270 GND.n269 97.5005
R714 GND.n107 GND 97.5005
R715 GND.n109 GND.n107 97.5005
R716 GND.n110 GND 97.5005
R717 GND.n111 GND.n110 97.5005
R718 GND.n56 GND.n55 97.0269
R719 GND.n357 GND.n356 93.0224
R720 GND.n254 GND.t15 91.826
R721 GND.t15 GND.n96 86.2818
R722 GND.n300 GND.t5 86.1921
R723 GND.t6 GND.n111 82.8036
R724 GND.t5 GND.n281 80.9881
R725 GND.n217 GND.n216 79.7892
R726 GND GND.t25 79.0672
R727 GND.n221 GND.n220 78.655
R728 GND.n303 GND.n265 78.655
R729 GND.n257 GND.n91 78.655
R730 GND.t36 GND.n270 77.7356
R731 GND.n289 GND.n287 76.8758
R732 GND.n242 GND.n240 76.8758
R733 GND.n138 GND.n137 76.8758
R734 GND.n144 GND.n127 73.1255
R735 GND.t3 GND.n127 73.1255
R736 GND.n128 GND.n126 73.1255
R737 GND.t3 GND.n126 73.1255
R738 GND.n249 GND.n97 73.1255
R739 GND.t15 GND.n97 73.1255
R740 GND.n253 GND.n252 73.1255
R741 GND.t15 GND.n253 73.1255
R742 GND.n295 GND.n282 73.1255
R743 GND.t5 GND.n282 73.1255
R744 GND.n299 GND.n298 73.1255
R745 GND.t5 GND.n299 73.1255
R746 GND.n276 GND.n272 73.1255
R747 GND.t36 GND.n272 73.1255
R748 GND.n275 GND.n271 73.1255
R749 GND.t36 GND.n271 73.1255
R750 GND.n103 GND.n101 73.1255
R751 GND.n101 GND.t8 73.1255
R752 GND.n102 GND.n100 73.1255
R753 GND.n100 GND.t8 73.1255
R754 GND.n208 GND.n113 73.1255
R755 GND.t6 GND.n113 73.1255
R756 GND.n207 GND.n112 73.1255
R757 GND.t6 GND.n112 73.1255
R758 GND.n142 GND.n141 71.3183
R759 GND.n145 GND.n144 64.0758
R760 GND.n296 GND.n295 64.0758
R761 GND.n250 GND.n249 64.0758
R762 GND.n213 GND.n109 62.747
R763 GND.n231 GND.n103 59.6711
R764 GND.n208 GND.n89 59.6711
R765 GND.n276 GND.n263 59.6711
R766 GND.n218 GND.t20 56.8447
R767 GND.t24 GND.n115 56.1265
R768 GND.n169 GND.t4 53.1518
R769 GND.n174 GND.t4 53.1518
R770 GND.t30 GND.n187 53.0033
R771 GND.n186 GND.t9 53.0033
R772 GND.n181 GND.t9 53.0033
R773 GND.n76 GND.n6 52.1889
R774 GND.n395 GND.n6 52.1889
R775 GND.n318 GND.n73 47.7786
R776 GND.n326 GND.n325 47.7786
R777 GND.n46 GND.n7 45.3285
R778 GND.n47 GND.n44 45.3285
R779 GND.n240 GND.n237 41.7862
R780 GND.t32 GND.n237 41.7862
R781 GND.n245 GND.n244 41.7862
R782 GND.t32 GND.n245 41.7862
R783 GND.n287 GND.n284 41.7862
R784 GND.t26 GND.n284 41.7862
R785 GND.n292 GND.n291 41.7862
R786 GND.t26 GND.n292 41.7862
R787 GND.n268 GND.n265 41.7862
R788 GND.t28 GND.n268 41.7862
R789 GND.n267 GND.n266 41.7862
R790 GND.t28 GND.n267 41.7862
R791 GND.n220 GND.n219 41.7862
R792 GND.n161 GND.n160 41.7862
R793 GND.n162 GND.n161 41.7862
R794 GND.n94 GND.n91 41.7862
R795 GND.t34 GND.n94 41.7862
R796 GND.n93 GND.n92 41.7862
R797 GND.t34 GND.n93 41.7862
R798 GND.n138 GND.n131 41.7862
R799 GND.n133 GND.n131 41.7862
R800 GND.n132 GND.n130 41.7862
R801 GND.n130 GND.n125 41.7862
R802 GND.n211 GND.n111 40.8824
R803 GND.n279 GND.n270 38.3802
R804 GND.n247 GND.n96 37.4237
R805 GND.n293 GND.n281 35.1276
R806 GND.n176 GND.n175 33.7994
R807 GND.n254 GND.n95 31.8795
R808 GND.n204 GND.n114 31.5242
R809 GND.n312 GND.n308 31.205
R810 GND.n300 GND.n280 29.9236
R811 GND.n369 GND.n368 29.8925
R812 GND.n384 GND.n17 29.8925
R813 GND.n216 GND.n213 28.6625
R814 GND.n183 GND.n182 26.5914
R815 GND.n182 GND.n181 26.5914
R816 GND.n185 GND 26.5914
R817 GND.n186 GND.n185 26.5914
R818 GND.n173 GND.n172 26.5914
R819 GND.n174 GND.n173 26.5914
R820 GND GND.n170 26.5914
R821 GND.n170 GND.n169 26.5914
R822 GND.n180 GND.n115 24.3255
R823 GND.n140 GND.n129 24.0315
R824 GND.n196 GND.n121 22.9908
R825 GND GND.t23 21.1687
R826 GND GND.t27 21.1687
R827 GND GND.t33 21.1687
R828 GND GND.t35 21.1687
R829 GND GND.t29 21.1687
R830 GND GND.t21 21.1687
R831 GND.n228 GND.n227 19.5005
R832 GND.t30 GND.n176 19.2044
R833 GND.n391 GND.n11 18.8005
R834 GND.n70 GND 15.035
R835 GND.n374 GND 14.9453
R836 GND.n197 GND.n120 14.7876
R837 GND.n231 GND.n230 14.51
R838 GND.n259 GND.n89 14.51
R839 GND.n305 GND.n263 14.51
R840 GND.n312 GND.n311 14.2869
R841 GND.n193 GND 13.9564
R842 GND.n193 GND.n192 13.8005
R843 GND.n322 GND.n2 13.3171
R844 GND.n145 GND.n104 13.2322
R845 GND.n296 GND.n264 13.2322
R846 GND.n250 GND.n90 13.2322
R847 GND.n289 GND.n288 12.0794
R848 GND.n242 GND.n241 12.0794
R849 GND.n137 GND.n136 12.0794
R850 GND.n222 GND.n221 11.6628
R851 GND.n304 GND.n303 11.6628
R852 GND.n258 GND.n257 11.6628
R853 GND.n198 GND.n197 11.3408
R854 GND.n194 GND.n88 11.3048
R855 GND.n308 GND.n307 11.1369
R856 GND.n86 GND.t2 10.1864
R857 GND.n56 GND.n33 9.80115
R858 GND.n65 GND.n42 9.80115
R859 GND.n59 GND.n29 9.80115
R860 GND.n124 GND.n122 9.59066
R861 GND.n187 GND.n124 9.59066
R862 GND.n123 GND 9.59066
R863 GND.n175 GND.n123 9.59066
R864 GND.n226 GND.n225 9.12965
R865 GND.n391 GND.n390 9.02014
R866 GND.n52 GND.n12 9.01568
R867 GND.n217 GND.n108 8.83584
R868 GND.n86 GND 8.2161
R869 GND.n136 GND 8.15682
R870 GND.n288 GND 8.15682
R871 GND.n241 GND 8.15682
R872 GND.n197 GND.n196 7.94494
R873 GND.n329 GND.n69 7.8005
R874 GND.n77 GND.n69 7.8005
R875 GND.n72 GND.n68 7.8005
R876 GND.n318 GND.n68 7.8005
R877 GND.n324 GND.n323 7.8005
R878 GND.n325 GND.n324 7.8005
R879 GND.n321 GND.n320 7.8005
R880 GND.n320 GND.n319 7.8005
R881 GND.n43 GND.n11 7.8005
R882 GND.n44 GND.n43 7.8005
R883 GND.n393 GND.n392 7.8005
R884 GND.n394 GND.n393 7.8005
R885 GND.n32 GND.n31 7.8005
R886 GND.n58 GND.n31 7.8005
R887 GND.n361 GND.n30 7.8005
R888 GND.n58 GND.n30 7.8005
R889 GND.n386 GND.n385 7.8005
R890 GND.n385 GND.n384 7.8005
R891 GND.n383 GND.n382 7.8005
R892 GND.n384 GND.n383 7.8005
R893 GND.n54 GND.n53 7.8005
R894 GND.n55 GND.n54 7.8005
R895 GND.n50 GND.n49 7.8005
R896 GND.n49 GND.n7 7.8005
R897 GND.n61 GND.n34 7.8005
R898 GND.n65 GND.n34 7.8005
R899 GND.n64 GND.n63 7.8005
R900 GND.n65 GND.n64 7.8005
R901 GND.n379 GND.n20 7.8005
R902 GND.n367 GND.n20 7.8005
R903 GND.n21 GND.n19 7.8005
R904 GND.n367 GND.n19 7.8005
R905 GND.n38 GND.n35 7.8005
R906 GND.n42 GND.n35 7.8005
R907 GND.n41 GND.n40 7.8005
R908 GND.n42 GND.n41 7.8005
R909 GND.n371 GND.n25 7.8005
R910 GND.n371 GND.n17 7.8005
R911 GND.n27 GND.n26 7.8005
R912 GND.n27 GND.n17 7.8005
R913 GND.n339 GND.n335 7.8005
R914 GND.n356 GND.n335 7.8005
R915 GND.n355 GND.n354 7.8005
R916 GND.n356 GND.n355 7.8005
R917 GND.n349 GND.n348 7.8005
R918 GND.n345 GND.n344 7.8005
R919 GND.n346 GND.n345 7.8005
R920 GND.n402 GND.n401 7.71479
R921 GND.n400 GND.n399 7.6255
R922 GND.n227 GND.n226 7.55732
R923 GND.n359 GND.n33 7.35098
R924 GND.n58 GND.n42 7.35098
R925 GND.n364 GND.n29 7.35098
R926 GND.n348 GND.n347 7.34823
R927 GND.n394 GND.n7 6.86095
R928 GND.n47 GND.n46 6.86095
R929 GND.n55 GND.n44 6.86095
R930 GND.n198 GND 6.31877
R931 GND.n352 GND.n351 6.23889
R932 GND.n388 GND.n13 6.23443
R933 GND.n199 GND.n198 6.1505
R934 GND.n377 GND.n23 6.13175
R935 GND.n378 GND.n377 6.04246
R936 GND.n351 GND.n350 5.788
R937 GND.n388 GND.n387 5.77907
R938 GND.n399 GND.n398 5.71657
R939 GND.n375 GND.n374 5.70139
R940 GND.n226 GND.n0 5.64595
R941 GND.n262 GND.n261 5.46641
R942 GND.n375 GND.n24 5.06211
R943 GND.n308 GND.n262 4.97777
R944 GND.n246 GND.t32 4.69813
R945 GND.n194 GND 4.59738
R946 GND.n228 GND 4.59112
R947 GND.n307 GND 4.59112
R948 GND.n261 GND 4.59112
R949 GND.n260 GND.n259 4.5005
R950 GND.n306 GND.n305 4.5005
R951 GND.n196 GND.n195 4.5005
R952 GND.n230 GND.n229 4.5005
R953 GND.n227 GND.n88 4.5005
R954 GND.n319 GND.n318 4.41079
R955 GND.n326 GND.n73 4.41079
R956 GND.n325 GND.n77 4.41079
R957 GND.n369 GND.n366 4.41079
R958 GND.n367 GND.n17 4.41079
R959 GND.n381 GND.n18 4.41079
R960 GND.n71 GND.n70 4.2255
R961 GND.t24 GND.n114 4.203
R962 GND.n212 GND.t34 3.81232
R963 GND.n260 GND 3.52071
R964 GND.n306 GND 3.52071
R965 GND.n229 GND 3.52071
R966 GND.n389 GND.n12 3.438
R967 GND.n70 GND.n2 3.42945
R968 GND.n181 GND.n180 3.07313
R969 GND.n262 GND.n88 3.02323
R970 GND.n313 GND.n312 3.01565
R971 GND.n397 GND.n396 2.9402
R972 GND.n396 GND.n395 2.9402
R973 GND.n75 GND.n74 2.9402
R974 GND.n76 GND.n75 2.9402
R975 GND.n225 GND.n224 2.89281
R976 GND.n224 GND.n223 2.89281
R977 GND.n223 GND 2.89281
R978 GND.n309 GND 2.89281
R979 GND.n310 GND.n309 2.89281
R980 GND.n311 GND.n310 2.89281
R981 GND.n390 GND.n1 2.74157
R982 GND.n156 GND.n87 2.62707
R983 GND.n374 GND.n373 2.6105
R984 GND.n317 GND.n81 2.45066
R985 GND.n314 GND.n313 2.2355
R986 GND.n85 GND.n83 2.12777
R987 GND.t1 GND.n83 2.12777
R988 GND.n84 GND.n82 2.12777
R989 GND.t1 GND.n82 2.12777
R990 GND.n155 GND.n152 2.12777
R991 GND.t7 GND.n152 2.12777
R992 GND.n159 GND.n158 2.12777
R993 GND.t7 GND.n159 2.12777
R994 GND.n400 GND.n1 2.09871
R995 GND.n399 GND.n2 2.07193
R996 GND.n53 GND.n52 2.0485
R997 GND.n376 GND.n375 2.04514
R998 GND.n390 GND.n389 1.99157
R999 GND GND.n402 1.85865
R1000 GND.n376 GND.n12 1.53621
R1001 GND.t7 GND.n151 1.32192
R1002 GND.n401 GND 1.2005
R1003 GND.n304 GND.n264 1.05606
R1004 GND.n258 GND.n90 1.05606
R1005 GND.n222 GND.n104 1.05606
R1006 GND.n192 GND.n191 0.873227
R1007 GND.n288 GND.n264 0.833833
R1008 GND.n241 GND.n90 0.833833
R1009 GND.n136 GND.n104 0.833833
R1010 GND.n398 GND 0.776258
R1011 GND GND.n71 0.6405
R1012 GND.n87 GND.n86 0.576636
R1013 GND.n402 GND 0.507406
R1014 GND.n377 GND.n376 0.5005
R1015 GND.n389 GND.n388 0.5005
R1016 GND.n351 GND.n1 0.5005
R1017 GND.n347 GND.n346 0.450284
R1018 GND.n401 GND.n400 0.3755
R1019 GND.n261 GND.n260 0.361611
R1020 GND.n307 GND.n306 0.361611
R1021 GND.n229 GND.n228 0.361611
R1022 GND.n305 GND.n304 0.319944
R1023 GND.n259 GND.n258 0.319944
R1024 GND.n230 GND.n222 0.319944
R1025 GND.n195 GND.n193 0.285222
R1026 GND.n199 GND.n119 0.237537
R1027 GND.n195 GND.n194 0.236611
R1028 GND.n313 GND.n87 0.119345
R1029 GND.n151 GND.t1 0.11777
R1030 GND GND.t16 0.0717857
R1031 GND.n223 GND.t17 0.0717857
R1032 GND.n224 GND.t18 0.0717857
R1033 GND.n225 GND.t19 0.0717857
R1034 GND.n311 GND.t10 0.0717857
R1035 GND.n310 GND.t11 0.0717857
R1036 GND.n309 GND.t12 0.0717857
R1037 GND GND.t13 0.0717857
R1038 GND.n0 GND 0.0505
R1039 GND GND.n0 0.00740608
C0 out x1.x4.XM5.S 0.09606f
C1 x1.x3.XM4.G VDD 2.01633f
C2 x1.x4.VINN x1.x2.XM5.S 0.04303f
C3 VDD x1.x4.XM5.S 0.10797f
C4 x1.x2.XM4.G x1.x2.XM5.S 0.27385f
C5 x5.out VDD 0.40136f
C6 x1.XC1.C1 out 0.46771f
C7 x1.x3.XM5.S out 0.04311f
C8 x1.x4.VINN x1.x1.XM4.G 0.11054f
C9 out x1.x4.XM4.G 0.14775f
C10 x1.XC1.C1 VDD 2.6653f
C11 x1.x4.VINN x1.x2.XM4.G 0
C12 x1.x3.XM5.S VDD 0.2606f
C13 x1.x1.XM5.S x1.x1.XM4.G 0.27385f
C14 VDD x1.x4.XM4.G 5.41879f
C15 x1.x1.XM5.S x1.x4.VINN 0.04708f
C16 out x1.x2.XM5.S 0.22466f
C17 x5.out x5.XR9.R2 0.02489f
C18 x1.XC1.C1 x1.x3.XM4.G 0.13418f
C19 x1.x3.XM5.S x1.x3.XM4.G 0.27385f
C20 VDD x1.x2.XM5.S 0.2606f
C21 x1.XC1.C1 x5.out 0.54985f
C22 x1.x4.XM5.S x1.x4.XM4.G 0.00852f
C23 x1.x4.VINN out 2.408f
C24 out x1.x2.XM4.G 0.13416f
C25 VDD x1.x1.XM4.G 2.01573f
C26 x1.x4.VINN VDD 3.37439f
C27 x1.x3.XM5.S x1.XC1.C1 0.22466f
C28 VDD x1.x2.XM4.G 2.01573f
C29 x1.x1.XM5.S VDD 0.2606f
C30 x1.x3.XM4.G x1.x4.VINN 0.11055f
C31 x5.out x1.x1.XM4.G 0.0026f
C32 x1.XC1.C1 x1.x2.XM5.S 0.04708f
C33 x1.x4.VINN x1.x4.XM5.S 0.05561f
C34 x5.out x1.x4.VINN 0.34469f
C35 out VDD 2.29003f
C36 x1.XC1.C1 x1.x1.XM4.G 0.13416f
C37 x1.XC1.C1 x1.x4.VINN 0.00538f
C38 x5.out x1.x1.XM5.S 0.04307f
C39 x1.XC1.C1 x1.x2.XM4.G 0.1106f
C40 x1.x3.XM5.S x1.x4.VINN 0.04708f
C41 x1.x4.VINN x1.x4.XM4.G 0.00496f
C42 x1.XC1.C1 x1.x1.XM5.S 0.22466f
C43 x1.x3.XM4.G out 0
C44 out GND 0.3511p
C45 b2 GND 2.07542f
C46 b1 GND 1.98306f
C47 b0 GND 1.98762f
C48 VDD GND 0.18107p
C49 x1.x2.XM5.S GND 2.43033f
C50 x1.x2.XM4.G GND 1.28256f
C51 x1.x1.XM5.S GND 2.43017f
C52 x1.x1.XM4.G GND 1.2784f
C53 x1.x4.XM5.S GND 2.77911f
C54 x1.x4.XM4.G GND 4.26474f
C55 x1.x3.XM5.S GND 2.43017f
C56 x1.XC1.C1 GND 0.33626p
C57 x1.x3.XM4.G GND 1.28178f
C58 x1.x4.VINN GND 29.1957f
C59 x5.out GND 16.5738f
C60 x5.XR11.R2 GND 5.64291f
C61 x5.XR8.R1 GND 2.95964f
C62 x5.XR6.R1 GND 3.00093f
C63 x5.XR10.R1 GND 4.66087f
C64 x5.XR4.R2 GND 2.99589f
C65 x5.XR9.R2 GND 4.62549f
C66 x5.XR2.R1 GND 2.6818f
C67 VDD.t0 GND 0.00702f
C68 VDD.n0 GND 0.05141f
C69 VDD.t3 GND 0.00217f
C70 VDD.n1 GND 0.0077f
C71 VDD.t2 GND 0.10652f
C72 VDD.n3 GND 0.07291f
C73 VDD.n4 GND 0.00787f
C74 VDD.n5 GND 0.00787f
C75 VDD.n7 GND 0.07291f
C76 VDD.n8 GND 0.00787f
C77 VDD.n9 GND 0.00418f
C78 VDD.n10 GND 0.00469f
C79 VDD.n11 GND 0.01755f
C80 VDD.t7 GND 0.00201f
C81 VDD.t26 GND 0.19577f
C82 VDD.t6 GND 0.00637f
C83 VDD.n12 GND 0.03514f
C84 VDD.n13 GND 0.09411f
C85 VDD.t5 GND 0.00217f
C86 VDD.n14 GND 0.00402f
C87 VDD.n15 GND 0.00787f
C88 VDD.n16 GND 0.00787f
C89 VDD.t4 GND 0.10652f
C90 VDD.n18 GND 0.07291f
C91 VDD.n19 GND 0.00787f
C92 VDD.n21 GND 0.07291f
C93 VDD.n22 GND 0.0077f
C94 VDD.n23 GND 0.00466f
C95 VDD.n24 GND 0.0114f
C96 VDD.n25 GND 0.05492f
C97 VDD.n26 GND 0.0371f
C98 VDD.n27 GND 0.09885f
C99 VDD.t13 GND 0.00813f
C100 VDD.t12 GND 0.01395f
C101 VDD.t29 GND 0.04863f
C102 VDD.n28 GND 0.03334f
C103 VDD.n29 GND 0.06814f
C104 VDD.t17 GND 0.01093f
C105 VDD.n30 GND 0.0058f
C106 VDD.n31 GND 0.04366f
C107 VDD.n32 GND 0.04366f
C108 VDD.n33 GND 0.00598f
C109 VDD.n34 GND 0.00598f
C110 VDD.t16 GND 0.07148f
C111 VDD.n37 GND 0.00598f
C112 VDD.n38 GND 0.0033f
C113 VDD.n39 GND 0.00484f
C114 VDD.n40 GND 0.01629f
C115 VDD.n41 GND 0.03764f
C116 VDD.t15 GND 0.01093f
C117 VDD.n42 GND 0.00326f
C118 VDD.n43 GND 0.00598f
C119 VDD.n44 GND 0.00598f
C120 VDD.t14 GND 0.07148f
C121 VDD.n45 GND 0.00612f
C122 VDD.n47 GND 0.04366f
C123 VDD.n48 GND 0.00598f
C124 VDD.n50 GND 0.04366f
C125 VDD.n51 GND 0.0041f
C126 VDD.n52 GND 0.01848f
C127 VDD.n53 GND 0.02911f
C128 VDD.n54 GND 0.04109f
C129 VDD.n55 GND 0.17955f
C130 VDD.t21 GND 0.01093f
C131 VDD.n56 GND 0.00612f
C132 VDD.n57 GND 0.04366f
C133 VDD.n58 GND 0.04366f
C134 VDD.n59 GND 0.00598f
C135 VDD.n60 GND 0.00598f
C136 VDD.t20 GND 0.07148f
C137 VDD.n63 GND 0.00598f
C138 VDD.n64 GND 0.00326f
C139 VDD.n65 GND 0.0041f
C140 VDD.n66 GND 0.01848f
C141 VDD.t11 GND 0.00813f
C142 VDD.t27 GND 0.04863f
C143 VDD.t10 GND 0.01395f
C144 VDD.n67 GND 0.03334f
C145 VDD.n68 GND 0.06814f
C146 VDD.t19 GND 0.01093f
C147 VDD.n69 GND 0.0033f
C148 VDD.n70 GND 0.00598f
C149 VDD.n71 GND 0.00598f
C150 VDD.t18 GND 0.07148f
C151 VDD.n73 GND 0.04366f
C152 VDD.n74 GND 0.00598f
C153 VDD.n76 GND 0.04366f
C154 VDD.n77 GND 0.0058f
C155 VDD.n78 GND 0.00484f
C156 VDD.n79 GND 0.01629f
C157 VDD.n80 GND 0.03764f
C158 VDD.n81 GND 0.02911f
C159 VDD.n82 GND 0.14507f
C160 VDD.n83 GND 0.22931f
C161 VDD.t23 GND 0.01093f
C162 VDD.n84 GND 0.00612f
C163 VDD.n85 GND 0.04366f
C164 VDD.n86 GND 0.04366f
C165 VDD.n87 GND 0.00598f
C166 VDD.n88 GND 0.00598f
C167 VDD.t22 GND 0.07148f
C168 VDD.n91 GND 0.00598f
C169 VDD.n92 GND 0.00326f
C170 VDD.n93 GND 0.0041f
C171 VDD.n94 GND 0.01848f
C172 VDD.t9 GND 0.00813f
C173 VDD.t28 GND 0.04863f
C174 VDD.t8 GND 0.01395f
C175 VDD.n95 GND 0.03334f
C176 VDD.n96 GND 0.06814f
C177 VDD.t25 GND 0.01093f
C178 VDD.n97 GND 0.0033f
C179 VDD.n98 GND 0.00598f
C180 VDD.n99 GND 0.00598f
C181 VDD.t24 GND 0.07148f
C182 VDD.n101 GND 0.04366f
C183 VDD.n102 GND 0.00598f
C184 VDD.n104 GND 0.04366f
C185 VDD.n105 GND 0.0058f
C186 VDD.n106 GND 0.00484f
C187 VDD.n107 GND 0.01629f
C188 VDD.n108 GND 0.03764f
C189 VDD.n109 GND 0.02911f
C190 VDD.n110 GND 0.11753f
C191 VDD.n111 GND 0.16848f
C192 VDD.n112 GND 0.05281f
C193 VDD.n113 GND 0.05564f
C194 VDD.n114 GND 2.30281f
C195 VDD.t1 GND 0.01247f
C196 out.t2 GND 0
C197 out.t0 GND 0
C198 out.n0 GND 0.00133f
C199 out.n1 GND 0.01566f
C200 out.t3 GND 0.00105f
C201 out.t1 GND 0
C202 out.n2 GND 0.00132f
C203 out.t8 GND 0.00662f
C204 out.t9 GND 0
C205 out.n3 GND 0.01459f
C206 out.n4 GND 0.02217f
C207 out.n5 GND 0.02165f
C208 out.t7 GND 1.41733f
C209 out.t6 GND 0.71904f
C210 out.n6 GND 0.70365f
C211 out.t5 GND 0.71904f
C212 out.n7 GND 0.70146f
C213 out.t4 GND 0.71904f
.ends
