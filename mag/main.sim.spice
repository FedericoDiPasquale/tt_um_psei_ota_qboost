* NGSPICE file created from main_parax.ext - technology: sky130A

.subckt main_parax VDD GND b0 b1 b2 out
X0 x5.out GND.t36 sky130_fd_pr__res_generic_po w=1 l=21
X1 VDD.t15 VDD.t14 GND.t26 GND.t25 sky130_fd_pr__nfet_01v8 ad=1.16 pd=8.58 as=1.16 ps=8.58 w=4 l=0.5
X2 out.t6 GND.t16 sky130_fd_pr__cap_mim_m3_1 l=30 w=30
X3 x5.out x5.XR11.R2 sky130_fd_pr__res_generic_po w=1 l=63
X4 b2.t0 x5.XR8.R1 sky130_fd_pr__res_generic_po w=1 l=21
X5 VDD.t3 x1.x3.XM4.G x1.XC1.C1 VDD.t2 sky130_fd_pr__pfet_01v8 ad=1.45 pd=10.58 as=1.45 ps=10.58 w=5 l=0.5
X6 VDD.t5 x1.x3.XM4.G x1.x3.XM4.G VDD.t4 sky130_fd_pr__pfet_01v8 ad=1.45 pd=10.58 as=1.45 ps=10.58 w=5 l=0.5
X7 VDD.t25 x1.x1.XM4.G x1.x1.XM4.G VDD.t24 sky130_fd_pr__pfet_01v8 ad=1.45 pd=10.58 as=1.45 ps=10.58 w=5 l=0.5
X8 VDD.t9 x1.x4.XM4.G x1.x4.XM4.G VDD.t8 sky130_fd_pr__pfet_01v8 ad=0.29 pd=2.58 as=0.29 ps=2.58 w=1 l=7
X9 out.t5 GND.t17 sky130_fd_pr__cap_mim_m3_1 l=30 w=30
X10 x1.XC1.C1 GND.t11 sky130_fd_pr__cap_mim_m3_1 l=30 w=30
X11 x5.XR2.R1 x5.XR9.R2 sky130_fd_pr__res_generic_po w=1 l=21
X12 x1.x3.XM5.S VDD.t29 GND.t20 GND.t19 sky130_fd_pr__nfet_01v8 ad=1.16 pd=8.58 as=1.16 ps=8.58 w=4 l=1.48
X13 out.t0 x1.x4.VINN x1.x4.XM5.S GND.t4 sky130_fd_pr__nfet_01v8 ad=0.145 pd=1.58 as=0.145 ps=1.58 w=0.5 l=7
X14 x1.x1.XM5.S VDD.t28 GND.t28 GND.t27 sky130_fd_pr__nfet_01v8 ad=1.16 pd=8.58 as=1.16 ps=8.58 w=4 l=1.48
X15 out.t1 x1.x4.VINN x1.x2.XM5.S GND.t6 sky130_fd_pr__nfet_01v8 ad=0.58 pd=4.58 as=0.58 ps=4.58 w=2 l=0.5
X16 out.t7 GND.t15 sky130_fd_pr__cap_mim_m3_1 l=30 w=30
X17 out.t4 GND.t18 sky130_fd_pr__cap_mim_m3_1 l=30 w=30
X18 GND.t2 x1.x4.VINN GND.t1 sky130_fd_pr__res_high_po_1p41 l=88.83
X19 x1.XC1.C1 GND.t9 sky130_fd_pr__cap_mim_m3_1 l=30 w=30
X20 x1.XC1.C1 GND.t12 sky130_fd_pr__cap_mim_m3_1 l=30 w=30
X21 VDD.t13 VDD.t12 GND.t24 GND.t23 sky130_fd_pr__nfet_01v8 ad=0.29 pd=2.58 as=0.29 ps=2.58 w=1 l=0.5
X22 b0.t0 x5.XR4.R2 sky130_fd_pr__res_generic_po w=1 l=21
X23 GND.t0 x5.XR2.R1 sky130_fd_pr__res_generic_po w=1 l=21
X24 VDD.t7 x1.x4.XM4.G out.t2 VDD.t6 sky130_fd_pr__pfet_01v8 ad=0.29 pd=2.58 as=0.29 ps=2.58 w=1 l=7
X25 VDD.t23 x1.x1.XM4.G x1.XC1.C1 VDD.t22 sky130_fd_pr__pfet_01v8 ad=1.45 pd=10.58 as=1.45 ps=10.58 w=5 l=0.5
X26 x5.XR4.R2 x5.XR9.R2 sky130_fd_pr__res_generic_po w=1 l=21
X27 x1.x3.XM4.G x1.x4.VINN x1.x3.XM5.S GND.t3 sky130_fd_pr__nfet_01v8 ad=0.58 pd=4.58 as=0.58 ps=4.58 w=2 l=0.5
X28 x1.x2.XM4.G x1.XC1.C1 x1.x2.XM5.S GND.t8 sky130_fd_pr__nfet_01v8 ad=0.58 pd=4.58 as=0.58 ps=4.58 w=2 l=0.5
X29 x1.XC1.C1 GND.t10 sky130_fd_pr__cap_mim_m3_1 l=30 w=30
X30 VDD.t11 VDD.t10 GND.t32 GND.t31 sky130_fd_pr__nfet_01v8 ad=1.16 pd=8.58 as=1.16 ps=8.58 w=4 l=0.5
X31 b1.t0 x5.XR6.R1 sky130_fd_pr__res_generic_po w=1 l=21
X32 VDD.t1 x5.out sky130_fd_pr__res_generic_po w=1 l=21
X33 x1.XC1.C1 out.t9 x1.x3.XM5.S GND.t13 sky130_fd_pr__nfet_01v8 ad=0.58 pd=4.58 as=0.58 ps=4.58 w=2 l=0.5
X34 x1.x4.XM4.G out.t8 x1.x4.XM5.S GND.t14 sky130_fd_pr__nfet_01v8 ad=0.145 pd=1.58 as=0.145 ps=1.58 w=0.5 l=7
X35 VDD.t19 x1.x2.XM4.G x1.x2.XM4.G VDD.t18 sky130_fd_pr__pfet_01v8 ad=1.45 pd=10.58 as=1.45 ps=10.58 w=5 l=0.5
X36 x5.XR9.R2 x5.XR10.R1 sky130_fd_pr__res_generic_po w=1 l=21
X37 VDD.t21 x1.x2.XM4.G out.t3 VDD.t20 sky130_fd_pr__pfet_01v8 ad=1.45 pd=10.58 as=1.45 ps=10.58 w=5 l=0.5
X38 VDD.t17 VDD.t16 GND.t22 GND.t21 sky130_fd_pr__nfet_01v8 ad=1.16 pd=8.58 as=1.16 ps=8.58 w=4 l=0.5
X39 x5.XR8.R1 x5.XR11.R2 sky130_fd_pr__res_generic_po w=1 l=21
X40 x1.XC1.C1 x5.out x1.x1.XM5.S GND.t35 sky130_fd_pr__nfet_01v8 ad=0.58 pd=4.58 as=0.58 ps=4.58 w=2 l=0.5
X41 x5.XR6.R1 x5.XR10.R1 sky130_fd_pr__res_generic_po w=1 l=21
X42 VDD.t0 x1.x4.VINN GND.t7 sky130_fd_pr__res_high_po_1p41 l=88.83
X43 x1.x4.XM5.S VDD.t26 GND.t30 GND.t29 sky130_fd_pr__nfet_01v8 ad=0.145 pd=1.58 as=0.145 ps=1.58 w=0.5 l=20
X44 x5.XR10.R1 x5.XR11.R2 sky130_fd_pr__res_generic_po w=1 l=21
X45 x1.x2.XM5.S VDD.t27 GND.t34 GND.t33 sky130_fd_pr__nfet_01v8 ad=1.16 pd=8.58 as=1.16 ps=8.58 w=4 l=1.48
X46 x1.x1.XM4.G x1.x4.VINN x1.x1.XM5.S GND.t5 sky130_fd_pr__nfet_01v8 ad=0.58 pd=4.58 as=0.58 ps=4.58 w=2 l=0.5
R0 out out.t9 285.474
R1 out.t9 out 274.911
R2 out out.t2 223.565
R3 out out.t0 219.8
R4 out out.t3 47.4992
R5 out out.t1 39.5338
R6 out.n7 out 31.3487
R7 out.n4 out.n2 26.1482
R8 out.n1 out 19.8925
R9 out.n3 out 14.1405
R10 out.n2 out 11.2789
R11 out out.t8 11.2155
R12 out out.n7 10.9835
R13 out.n3 out 9.52394
R14 out.n7 out.n4 8.80732
R15 out.n0 out 6.77178
R16 out out.n3 5.92238
R17 out out.n0 5.82436
R18 out.n4 out 5.67664
R19 out.n0 out 5.58145
R20 out.n2 out.n1 4.5005
R21 out.n1 out 0.813
R22 out.n5 out.t4 0.264341
R23 out.n6 out.n5 0.263519
R24 out out.n6 0.263519
R25 out.n5 out.t5 0.00132177
R26 out.n6 out.t6 0.00132177
R27 out out.t7 0.00132177
R28 b2 b2.t0 171.678
R29 b1 b1.t0 171.678
R30 b0 b0.t0 171.678
R31 VDD.n21 VDD.n16 3854.12
R32 VDD.n19 VDD.n18 3854.12
R33 VDD.n8 VDD.n7 3854.12
R34 VDD.n5 VDD.n3 3854.12
R35 VDD.n104 VDD.n99 2971.76
R36 VDD.n102 VDD.n101 2971.76
R37 VDD.n91 VDD.n85 2971.76
R38 VDD.n88 VDD.n86 2971.76
R39 VDD.n76 VDD.n71 2971.76
R40 VDD.n74 VDD.n73 2971.76
R41 VDD.n63 VDD.n57 2971.76
R42 VDD.n60 VDD.n58 2971.76
R43 VDD.n50 VDD.n44 2971.76
R44 VDD.n48 VDD.n47 2971.76
R45 VDD.n37 VDD.n31 2971.76
R46 VDD.n34 VDD.n32 2971.76
R47 VDD.n101 VDD.n100 924.852
R48 VDD.n104 VDD.n103 924.852
R49 VDD.n89 VDD.n85 924.852
R50 VDD.n90 VDD.n86 924.852
R51 VDD.n73 VDD.n72 924.852
R52 VDD.n76 VDD.n75 924.852
R53 VDD.n61 VDD.n57 924.852
R54 VDD.n62 VDD.n58 924.852
R55 VDD.n47 VDD.n46 924.852
R56 VDD.n50 VDD.n49 924.852
R57 VDD.n35 VDD.n31 924.852
R58 VDD.n36 VDD.n32 924.852
R59 VDD.n22 VDD.n15 411.106
R60 VDD VDD.n15 411.106
R61 VDD.n4 VDD.n1 411.106
R62 VDD.n4 VDD 411.106
R63 VDD VDD.n14 409.243
R64 VDD.n23 VDD.n22 406.212
R65 VDD.n9 VDD.n1 404.981
R66 VDD.n10 VDD 403.462
R67 VDD.n95 VDD.t14 381.204
R68 VDD.n67 VDD.t10 381.204
R69 VDD.n28 VDD.t16 381.204
R70 VDD.t14 VDD 371.31
R71 VDD.t10 VDD 371.31
R72 VDD.t16 VDD 371.31
R73 VDD.n105 VDD.n98 316.988
R74 VDD VDD.n98 316.988
R75 VDD VDD.n97 316.988
R76 VDD.n92 VDD.n84 316.988
R77 VDD.n87 VDD.n84 316.988
R78 VDD.n87 VDD 316.988
R79 VDD.n77 VDD.n70 316.988
R80 VDD VDD.n70 316.988
R81 VDD VDD.n69 316.988
R82 VDD.n64 VDD.n56 316.988
R83 VDD.n59 VDD.n56 316.988
R84 VDD.n59 VDD 316.988
R85 VDD VDD.n43 316.988
R86 VDD.n45 VDD.n43 316.988
R87 VDD.n45 VDD.n42 316.988
R88 VDD.n38 VDD 316.988
R89 VDD.n33 VDD 316.988
R90 VDD.n33 VDD.n30 316.988
R91 VDD.n93 VDD 286.495
R92 VDD.n65 VDD 286.495
R93 VDD.n51 VDD 286.495
R94 VDD.n106 VDD.n105 282.084
R95 VDD.n78 VDD.n77 282.084
R96 VDD.n39 VDD.n30 282.084
R97 VDD.n12 VDD.t12 237.002
R98 VDD.t12 VDD 226.71
R99 VDD VDD.t9 223.565
R100 VDD VDD.t7 223.565
R101 VDD VDD.t1 171.678
R102 VDD.n18 VDD.n17 142.75
R103 VDD.n21 VDD.n20 142.75
R104 VDD.n3 VDD.n2 142.75
R105 VDD.n7 VDD.n6 142.75
R106 VDD VDD.t28 112.091
R107 VDD VDD.t27 112.091
R108 VDD VDD.t29 112.091
R109 VDD VDD.t13 79.0672
R110 VDD.n105 VDD.n104 61.6672
R111 VDD.n101 VDD 61.6672
R112 VDD.n85 VDD.n84 61.6672
R113 VDD.n86 VDD 61.6672
R114 VDD.n77 VDD.n76 61.6672
R115 VDD.n73 VDD 61.6672
R116 VDD.n57 VDD.n56 61.6672
R117 VDD.n58 VDD 61.6672
R118 VDD VDD.n50 61.6672
R119 VDD.n47 VDD.n45 61.6672
R120 VDD.n31 VDD 61.6672
R121 VDD.n32 VDD.n30 61.6672
R122 VDD VDD.t25 47.4992
R123 VDD VDD.t23 47.4992
R124 VDD VDD.t19 47.4992
R125 VDD VDD.t21 47.4992
R126 VDD VDD.t3 47.4992
R127 VDD VDD.t5 47.4992
R128 VDD VDD.n114 33.5353
R129 VDD.n19 VDD.n15 30.8338
R130 VDD.n16 VDD.n14 30.8338
R131 VDD.n5 VDD.n4 30.8338
R132 VDD.n9 VDD.n8 30.8338
R133 VDD.n17 VDD.n16 29.4567
R134 VDD.n20 VDD.n19 29.4567
R135 VDD.n8 VDD.n2 29.4567
R136 VDD.n6 VDD.n5 29.4567
R137 VDD.n83 VDD.n82 26.1321
R138 VDD VDD.t15 21.1687
R139 VDD VDD.t11 21.1687
R140 VDD VDD.t17 21.1687
R141 VDD.n93 VDD.n92 18.4476
R142 VDD.n65 VDD.n64 18.4476
R143 VDD.n51 VDD.n42 18.4476
R144 VDD.n113 VDD 16.0646
R145 VDD.n106 VDD.n97 15.5434
R146 VDD.n78 VDD.n69 15.5434
R147 VDD.n39 VDD.n38 15.5434
R148 VDD.n96 VDD.n95 15.4443
R149 VDD.n68 VDD.n67 15.4443
R150 VDD.n29 VDD.n28 15.4443
R151 VDD.n55 VDD.n27 15.4198
R152 VDD.n13 VDD.n12 15.217
R153 VDD.n25 VDD.n13 14.6786
R154 VDD.n24 VDD.n23 13.8005
R155 VDD.n112 VDD.n111 13.33
R156 VDD.n111 VDD.n110 12.223
R157 VDD.n107 VDD.n106 11.5505
R158 VDD.n94 VDD.n93 11.5505
R159 VDD.n79 VDD.n78 11.5505
R160 VDD.n66 VDD.n65 11.5505
R161 VDD.n52 VDD.n51 11.5505
R162 VDD.n40 VDD.n39 11.5505
R163 VDD.n11 VDD.n10 11.5505
R164 VDD.n102 VDD.n98 10.8829
R165 VDD.n99 VDD.n97 10.8829
R166 VDD.n92 VDD.n91 10.8829
R167 VDD.n88 VDD.n87 10.8829
R168 VDD.n74 VDD.n70 10.8829
R169 VDD.n71 VDD.n69 10.8829
R170 VDD.n64 VDD.n63 10.8829
R171 VDD.n60 VDD.n59 10.8829
R172 VDD.n48 VDD.n43 10.8829
R173 VDD.n44 VDD.n42 10.8829
R174 VDD.n38 VDD.n37 10.8829
R175 VDD.n34 VDD.n33 10.8829
R176 VDD.n0 VDD.t0 10.1864
R177 VDD.n24 VDD 9.29564
R178 VDD.n11 VDD 9.29224
R179 VDD.n22 VDD.n21 8.40959
R180 VDD.n18 VDD 8.40959
R181 VDD.n7 VDD.n1 8.40959
R182 VDD.n3 VDD 8.40959
R183 VDD.n0 VDD 8.2161
R184 VDD.n108 VDD.n96 7.70242
R185 VDD.n80 VDD.n68 7.70242
R186 VDD.n41 VDD.n29 7.70242
R187 VDD.n26 VDD.n11 7.50943
R188 VDD.n100 VDD.n99 7.46928
R189 VDD.n103 VDD.n102 7.46928
R190 VDD.n72 VDD.n71 7.46928
R191 VDD.n75 VDD.n74 7.46928
R192 VDD.n46 VDD.n44 7.46928
R193 VDD.n49 VDD.n48 7.46928
R194 VDD.n91 VDD.n90 7.46927
R195 VDD.n89 VDD.n88 7.46927
R196 VDD.n63 VDD.n62 7.46927
R197 VDD.n61 VDD.n60 7.46927
R198 VDD.n37 VDD.n36 7.46927
R199 VDD.n35 VDD.n34 7.46927
R200 VDD.n13 VDD 6.60988
R201 VDD.n96 VDD 6.37373
R202 VDD.n68 VDD 6.37373
R203 VDD.n29 VDD 6.37373
R204 VDD.n55 VDD.n54 6.15478
R205 VDD.n111 VDD.n83 5.71641
R206 VDD.n27 VDD.n26 4.98488
R207 VDD.n25 VDD.n24 4.87029
R208 VDD.n83 VDD.n55 4.56868
R209 VDD.n110 VDD 4.56613
R210 VDD.n82 VDD 4.56613
R211 VDD.n27 VDD 4.563
R212 VDD.n54 VDD 4.53488
R213 VDD VDD.t26 3.88644
R214 VDD.n109 VDD.n94 3.50493
R215 VDD.n81 VDD.n66 3.50493
R216 VDD.n53 VDD.n52 3.50493
R217 VDD.n103 VDD.t24 3.38773
R218 VDD.n100 VDD.t24 3.38773
R219 VDD.n75 VDD.t18 3.38773
R220 VDD.n72 VDD.t18 3.38773
R221 VDD.n49 VDD.t2 3.38773
R222 VDD.n46 VDD.t2 3.38773
R223 VDD.n90 VDD.t22 3.38773
R224 VDD.t22 VDD.n89 3.38773
R225 VDD.n62 VDD.t20 3.38773
R226 VDD.t20 VDD.n61 3.38773
R227 VDD.n36 VDD.t4 3.38773
R228 VDD.t4 VDD.n35 3.38773
R229 VDD.n114 VDD.n113 3.30909
R230 VDD.n94 VDD 3.13354
R231 VDD.n66 VDD 3.13354
R232 VDD.n52 VDD 3.13354
R233 VDD.n107 VDD 3.12662
R234 VDD.n79 VDD 3.12662
R235 VDD.n40 VDD 3.12662
R236 VDD.n95 VDD 2.60425
R237 VDD.n67 VDD 2.60425
R238 VDD.n28 VDD 2.60425
R239 VDD.n110 VDD.n109 2.60146
R240 VDD.n82 VDD.n81 2.60146
R241 VDD.n54 VDD.n53 2.60146
R242 VDD.n26 VDD.n25 2.54738
R243 VDD.n108 VDD.n107 2.48264
R244 VDD.n80 VDD.n79 2.48264
R245 VDD.n41 VDD.n40 2.48264
R246 VDD.n23 VDD.n14 2.2405
R247 VDD.n12 VDD 1.64459
R248 VDD.n114 VDD 1.19304
R249 VDD.n113 VDD 1.19112
R250 VDD.n20 VDD.t8 1.143
R251 VDD.n17 VDD.t8 1.143
R252 VDD.n6 VDD.t6 1.143
R253 VDD.t6 VDD.n2 1.143
R254 VDD.n109 VDD.n108 1.02279
R255 VDD.n81 VDD.n80 1.02279
R256 VDD.n53 VDD.n41 1.02279
R257 VDD.n112 VDD.n0 0.855594
R258 VDD.n10 VDD.n9 0.738962
R259 VDD VDD.n112 0.358455
R260 GND.n389 GND.n9 4.19441e+07
R261 GND.n242 GND.n9 1.88991e+06
R262 GND.n390 GND.n389 1.8898e+06
R263 GND.n392 GND.t1 56449
R264 GND.n55 GND.n21 55907.4
R265 GND.n378 GND.n21 55907.4
R266 GND.n55 GND.n22 55907.4
R267 GND.n378 GND.n22 55907.4
R268 GND.n75 GND.n66 55907.4
R269 GND.n75 GND.n67 55907.4
R270 GND.n70 GND.n66 55907.4
R271 GND.n70 GND.n67 55907.4
R272 GND.n245 GND.n206 40784.8
R273 GND.n368 GND.n206 40784.8
R274 GND.n245 GND.n243 40784.8
R275 GND.n368 GND.n243 40784.8
R276 GND.n157 GND.t1 26534.5
R277 GND.n391 GND.n390 24146.7
R278 GND.n392 GND.n391 19923.7
R279 GND.n282 GND.n280 16449.5
R280 GND.n286 GND.n280 16449.5
R281 GND.n283 GND.n282 16449.5
R282 GND.n286 GND.n283 16449.5
R283 GND.n315 GND.n299 16449.5
R284 GND.n319 GND.n299 16449.5
R285 GND.n315 GND.n313 16449.5
R286 GND.n319 GND.n313 16449.5
R287 GND.n341 GND.n269 16449.5
R288 GND.n275 GND.n269 16449.5
R289 GND.n341 GND.n273 16449.5
R290 GND.n275 GND.n273 16449.5
R291 GND.n326 GND.n296 16449.5
R292 GND.n322 GND.n296 16449.5
R293 GND.n326 GND.n297 16449.5
R294 GND.n322 GND.n297 16449.5
R295 GND.n352 GND.n261 16449.5
R296 GND.n352 GND.n262 16449.5
R297 GND.n261 GND.n259 16449.5
R298 GND.n262 GND.n259 16449.5
R299 GND.n302 GND.n265 16449.5
R300 GND.n344 GND.n265 16449.5
R301 GND.n302 GND.n266 16449.5
R302 GND.n344 GND.n266 16449.5
R303 GND.n355 GND.n256 16449.5
R304 GND.n355 GND.n257 16449.5
R305 GND.n357 GND.n256 16449.5
R306 GND.n357 GND.n257 16449.5
R307 GND.n310 GND.n305 16449.5
R308 GND.n310 GND.n306 16449.5
R309 GND.n305 GND.n301 16449.5
R310 GND.n306 GND.n301 16449.5
R311 GND.n331 GND.n292 16449.5
R312 GND.n331 GND.n293 16449.5
R313 GND.n333 GND.n292 16449.5
R314 GND.n333 GND.n293 16449.5
R315 GND.n365 GND.n249 16449.5
R316 GND.n329 GND.n249 16449.5
R317 GND.n365 GND.n250 16449.5
R318 GND.n329 GND.n250 16449.5
R319 GND.n375 GND.n24 16449.5
R320 GND.n34 GND.n24 16449.5
R321 GND.n375 GND.n25 16449.5
R322 GND.n34 GND.n25 16449.5
R323 GND.n37 GND.n30 16449.5
R324 GND.n37 GND.n31 16449.5
R325 GND.n39 GND.n30 16449.5
R326 GND.n39 GND.n31 16449.5
R327 GND.n80 GND.n51 13517.7
R328 GND.n84 GND.n51 13517.7
R329 GND.n80 GND.n52 13517.7
R330 GND.n84 GND.n52 13517.7
R331 GND.n163 GND.n155 7702.73
R332 GND.n87 GND.n49 5985.32
R333 GND.n91 GND.n49 5985.32
R334 GND.n87 GND.n50 5985.32
R335 GND.n91 GND.n50 5985.32
R336 GND.n63 GND.n57 5985.32
R337 GND.n59 GND.n57 5985.32
R338 GND.n63 GND.n58 5985.32
R339 GND.n59 GND.n58 5985.32
R340 GND.n224 GND.n217 4814.91
R341 GND.n228 GND.n217 4814.91
R342 GND.n224 GND.n218 4814.91
R343 GND.n228 GND.n218 4814.91
R344 GND.n169 GND.n105 4814.91
R345 GND.n165 GND.n105 4814.91
R346 GND.n165 GND.n106 4814.91
R347 GND.n169 GND.n106 4814.91
R348 GND.n132 GND.n118 4814.91
R349 GND.n134 GND.n118 4814.91
R350 GND.n133 GND.n132 4814.91
R351 GND.n134 GND.n133 4814.91
R352 GND.n65 GND.n64 4520.83
R353 GND.n230 GND.n207 4247.09
R354 GND.n240 GND.n207 4247.09
R355 GND.n230 GND.n208 4247.09
R356 GND.n240 GND.n208 4247.09
R357 GND.n144 GND.n140 4247.09
R358 GND.n146 GND.n140 4247.09
R359 GND.n146 GND.n145 4247.09
R360 GND.n145 GND.n144 4247.09
R361 GND.n180 GND.n95 4247.09
R362 GND.n180 GND.n96 4247.09
R363 GND.n102 GND.n95 4247.09
R364 GND.n102 GND.n96 4247.09
R365 GND.n242 GND.n241 3869.92
R366 GND.n391 GND.n6 3674.71
R367 GND.n74 GND.n73 3632.56
R368 GND.n74 GND 3632.56
R369 GND.n71 GND 3632.56
R370 GND.n379 GND.n20 3632.56
R371 GND GND.n20 3632.56
R372 GND GND.n19 3632.56
R373 GND.n72 GND.n71 3375.28
R374 GND.n380 GND.n19 3375.28
R375 GND.n182 GND.t1 3247.14
R376 GND.n215 GND.n213 3088.26
R377 GND.n233 GND.n213 3088.26
R378 GND.n215 GND.n214 3088.26
R379 GND.n233 GND.n214 3088.26
R380 GND.n161 GND.n4 3088.26
R381 GND.n394 GND.n4 3088.26
R382 GND.n161 GND.n5 3088.26
R383 GND.n394 GND.n5 3088.26
R384 GND.n172 GND.n100 3088.26
R385 GND.n172 GND.n101 3088.26
R386 GND.n173 GND.n100 3088.26
R387 GND.n173 GND.n101 3088.26
R388 GND.n125 GND.n119 3088.26
R389 GND.n129 GND.n119 3088.26
R390 GND.n125 GND.n120 3088.26
R391 GND.n129 GND.n120 3088.26
R392 GND.n153 GND.n109 3088.26
R393 GND.n141 GND.n109 3088.26
R394 GND.n153 GND.n110 3088.26
R395 GND.n141 GND.n110 3088.26
R396 GND.n387 GND.n11 3088.26
R397 GND.n387 GND.n12 3088.26
R398 GND.n221 GND.n11 3088.26
R399 GND.n221 GND.n12 3088.26
R400 GND.n78 GND.n77 2882.64
R401 GND.n377 GND.n376 2840.02
R402 GND.n369 GND.n205 2649.98
R403 GND.n244 GND.n205 2649.98
R404 GND.n244 GND 2630.63
R405 GND.n370 GND.n369 2628.39
R406 GND.t19 GND.n157 2571.08
R407 GND.n93 GND.n47 2508.85
R408 GND.n184 GND.n47 2508.85
R409 GND.n184 GND.n48 2508.85
R410 GND.n93 GND.n48 2508.85
R411 GND.n156 GND.n106 1994.52
R412 GND.n390 GND.n8 1573.59
R413 GND.n77 GND.n76 1158.54
R414 GND.n27 GND.n26 1068.8
R415 GND.n374 GND.n26 1068.8
R416 GND.n374 GND 1068.8
R417 GND.n358 GND.n255 1068.8
R418 GND.n354 GND.n255 1068.8
R419 GND.n354 GND 1068.8
R420 GND.n309 GND.n308 1068.8
R421 GND.n309 GND 1068.8
R422 GND GND.n307 1068.8
R423 GND.n364 GND.n251 1068.8
R424 GND.n364 GND 1068.8
R425 GND.n350 GND.n349 1068.8
R426 GND.n351 GND.n350 1068.8
R427 GND.n351 GND 1068.8
R428 GND.n345 GND.n264 1068.8
R429 GND GND.n264 1068.8
R430 GND GND.n263 1068.8
R431 GND GND.n291 1068.8
R432 GND.n334 GND.n291 1068.8
R433 GND.n276 GND 1068.8
R434 GND GND.n274 1068.8
R435 GND.n340 GND.n274 1068.8
R436 GND.n323 GND 1068.8
R437 GND.n325 GND.n323 1068.8
R438 GND.n325 GND.n324 1068.8
R439 GND GND.n279 1068.8
R440 GND.n281 GND.n279 1068.8
R441 GND.n281 GND.n278 1068.8
R442 GND.n318 GND.n314 1068.8
R443 GND GND.n314 1068.8
R444 GND.n316 GND 1068.8
R445 GND.n36 GND.n28 1068.8
R446 GND.n36 GND.n29 1068.8
R447 GND.n252 GND.n251 1067.74
R448 GND GND.n290 1057.72
R449 GND.n335 GND.n334 1053.74
R450 GND GND.n29 1043.69
R451 GND.n40 GND.n28 1041.32
R452 GND GND.n363 1015.76
R453 GND.n349 GND.n348 893.741
R454 GND.n83 GND.n53 878.307
R455 GND GND.n53 878.307
R456 GND.n359 GND.n358 877.616
R457 GND.n83 GND.n82 874.712
R458 GND.n81 GND 873.327
R459 GND.n324 GND.n277 843.672
R460 GND.n339 GND.n276 842.165
R461 GND.n317 GND.n316 832.269
R462 GND.n307 GND.n254 828.552
R463 GND.n287 GND.n278 828.111
R464 GND.n390 GND.n7 825.037
R465 GND.n346 GND.n263 821.082
R466 GND.n389 GND.n10 814.634
R467 GND.n22 GND.t1 779.318
R468 GND.n69 GND.t7 777.192
R469 GND.n68 GND.t1 777.192
R470 GND.n69 GND.n68 752.712
R471 GND.n303 GND.n300 660.822
R472 GND.n321 GND.n298 660.822
R473 GND.n272 GND.n271 642.845
R474 GND.n353 GND.n260 642.845
R475 GND.n389 GND.n388 615.476
R476 GND.n76 GND.n75 609.747
R477 GND.n33 GND.n9 586.086
R478 GND GND.n373 567.04
R479 GND.n373 GND.n27 412.312
R480 GND.n88 GND 388.894
R481 GND.n90 GND.n88 388.894
R482 GND.n90 GND.n89 388.894
R483 GND GND.n61 388.894
R484 GND.n61 GND.n60 388.894
R485 GND GND.n62 388.894
R486 GND.n183 GND.n182 344.122
R487 GND.n227 GND.n219 312.848
R488 GND GND.n219 312.848
R489 GND.n225 GND 312.848
R490 GND.n168 GND.n107 312.848
R491 GND GND.n107 312.848
R492 GND.n166 GND 312.848
R493 GND.n135 GND.n117 312.848
R494 GND GND.n117 312.848
R495 GND GND.n116 312.848
R496 GND.n393 GND.n392 312.183
R497 GND.n182 GND.n181 310.099
R498 GND.n79 GND.n54 287.839
R499 GND.n393 GND.t13 276.55
R500 GND GND.n209 275.954
R501 GND.n239 GND.n209 275.954
R502 GND GND.n210 275.954
R503 GND GND.n139 275.954
R504 GND.n147 GND.n139 275.954
R505 GND GND.n138 275.954
R506 GND GND.n98 275.954
R507 GND GND.n97 275.954
R508 GND.n179 GND.n97 275.954
R509 GND.n86 GND.n85 259.322
R510 GND.n158 GND.n104 234.885
R511 GND GND.t30 219.8
R512 GND.n346 GND.n345 218.353
R513 GND.n227 GND.n226 216.066
R514 GND.n168 GND.n167 216.066
R515 GND.n136 GND.n135 216.066
R516 GND.n308 GND.n254 206.245
R517 GND.t3 GND.n170 205.427
R518 GND.n60 GND.n43 204.518
R519 GND.n234 GND.n212 200.66
R520 GND GND.n212 200.66
R521 GND GND.n211 200.66
R522 GND.n160 GND.n3 200.66
R523 GND GND.n3 200.66
R524 GND.n160 GND.n2 200.66
R525 GND.n171 GND.n99 200.66
R526 GND.n171 GND 200.66
R527 GND.n174 GND 200.66
R528 GND.n112 GND.n111 200.66
R529 GND GND.n111 200.66
R530 GND GND.n152 200.66
R531 GND.n128 GND.n127 200.66
R532 GND.n128 GND.n121 200.66
R533 GND GND.n121 200.66
R534 GND.n220 GND.n14 200.66
R535 GND.n220 GND.n13 200.66
R536 GND GND.n13 200.66
R537 GND.n89 GND.n44 198.589
R538 GND.n159 GND.n156 197.685
R539 GND.n101 GND 195
R540 GND.n104 GND.n101 195
R541 GND.n144 GND 195
R542 GND.n144 GND.n143 195
R543 GND.n141 GND.n112 195
R544 GND.n142 GND.n141 195
R545 GND.n153 GND 195
R546 GND.n154 GND.n153 195
R547 GND.n129 GND.n128 195
R548 GND.n130 GND.n129 195
R549 GND GND.n125 195
R550 GND.n125 GND.n124 195
R551 GND GND.n394 195
R552 GND.n394 GND.n393 195
R553 GND.n161 GND.n160 195
R554 GND.n162 GND.n161 195
R555 GND.n147 GND.n146 195
R556 GND.n146 GND.n10 195
R557 GND.n240 GND.n239 195
R558 GND.n241 GND.n240 195
R559 GND.n230 GND 195
R560 GND.n231 GND.n230 195
R561 GND.n234 GND.n233 195
R562 GND.n233 GND.n232 195
R563 GND.n215 GND 195
R564 GND.n216 GND.n215 195
R565 GND.n221 GND.n220 195
R566 GND.n222 GND.n221 195
R567 GND.n387 GND 195
R568 GND.n388 GND.n387 195
R569 GND.n93 GND 195
R570 GND.n94 GND.n93 195
R571 GND.n185 GND.n184 195
R572 GND.n184 GND.n183 195
R573 GND.n100 GND.n99 195
R574 GND.n122 GND.n100 195
R575 GND.n102 GND 195
R576 GND.n103 GND.n102 195
R577 GND.n180 GND.n179 195
R578 GND.n181 GND.n180 195
R579 GND.n367 GND.n366 194.678
R580 GND.t3 GND.n103 193.024
R581 GND.n318 GND.n317 188.129
R582 GND.n340 GND.n339 185.976
R583 GND.n164 GND.t13 185.142
R584 GND GND.n277 184.471
R585 GND.n239 GND.n238 183.417
R586 GND.n148 GND.n147 183.417
R587 GND.n179 GND.n178 183.417
R588 GND.n62 GND.n43 177.036
R589 GND GND.t36 171.678
R590 GND GND.t0 171.678
R591 GND.n343 GND.n342 169.507
R592 GND GND.n44 165.835
R593 GND.n185 GND.n46 163.012
R594 GND GND.n46 163.012
R595 GND.n73 GND.n72 162.862
R596 GND.n380 GND.n379 162.862
R597 GND.n284 GND.n262 153.956
R598 GND.n359 GND 153.663
R599 GND.t31 GND.n10 151.959
R600 GND.n241 GND.t25 151.959
R601 GND GND.n45 151.299
R602 GND.n186 GND.n185 150.784
R603 GND.n287 GND 149.333
R604 GND GND.n39 146.25
R605 GND.n39 GND.n38 146.25
R606 GND.n37 GND.n36 146.25
R607 GND.n38 GND.n37 146.25
R608 GND GND.n25 146.25
R609 GND.n32 GND.n25 146.25
R610 GND.n26 GND.n24 146.25
R611 GND.n32 GND.n24 146.25
R612 GND.n308 GND.n306 146.25
R613 GND.n306 GND.n267 146.25
R614 GND GND.n305 146.25
R615 GND.n305 GND.n304 146.25
R616 GND.n257 GND.n255 146.25
R617 GND.n284 GND.n257 146.25
R618 GND.n256 GND 146.25
R619 GND.n270 GND.n256 146.25
R620 GND GND.n250 146.25
R621 GND.n294 GND.n250 146.25
R622 GND.n251 GND.n249 146.25
R623 GND.n294 GND.n249 146.25
R624 GND.n345 GND.n344 146.25
R625 GND.n344 GND.n343 146.25
R626 GND.n302 GND 146.25
R627 GND.n303 GND.n302 146.25
R628 GND.n350 GND.n262 146.25
R629 GND GND.n261 146.25
R630 GND.n271 GND.n261 146.25
R631 GND.n206 GND.n205 146.25
R632 GND.n247 GND.n206 146.25
R633 GND.n334 GND.n333 146.25
R634 GND.n333 GND.n332 146.25
R635 GND.n331 GND 146.25
R636 GND.n332 GND.n331 146.25
R637 GND GND.n322 146.25
R638 GND.n322 GND.n321 146.25
R639 GND.n326 GND.n325 146.25
R640 GND.n327 GND.n326 146.25
R641 GND GND.n275 146.25
R642 GND.n275 GND.n260 146.25
R643 GND.n341 GND.n340 146.25
R644 GND.n342 GND.n341 146.25
R645 GND.n319 GND.n318 146.25
R646 GND.n320 GND.n319 146.25
R647 GND GND.n315 146.25
R648 GND.n315 GND.n295 146.25
R649 GND GND.n286 146.25
R650 GND.n286 GND.n285 146.25
R651 GND.n282 GND.n281 146.25
R652 GND.n282 GND.n268 146.25
R653 GND.n243 GND 146.25
R654 GND.n243 GND.n242 146.25
R655 GND.n62 GND.n58 146.25
R656 GND.n58 GND.t4 146.25
R657 GND.n61 GND.n57 146.25
R658 GND.n57 GND.t4 146.25
R659 GND.n82 GND.n52 146.25
R660 GND.n52 GND.t29 146.25
R661 GND.n53 GND.n51 146.25
R662 GND.n51 GND.t29 146.25
R663 GND.n89 GND.n50 146.25
R664 GND.n50 GND.t14 146.25
R665 GND.n88 GND.n49 146.25
R666 GND.n49 GND.t14 146.25
R667 GND.n348 GND 135.906
R668 GND.n246 GND.n9 129.442
R669 GND.t27 GND.n216 126.861
R670 GND.n130 GND.t33 126.249
R671 GND.n158 GND.t19 125.582
R672 GND.n395 GND 124.047
R673 GND.n126 GND 124.047
R674 GND GND.n386 124.047
R675 GND.n232 GND.t25 122.496
R676 GND.n142 GND.n6 121.088
R677 GND.n235 GND.n234 120.922
R678 GND.n175 GND.n99 120.922
R679 GND.n151 GND.n112 120.922
R680 GND.n222 GND.t27 119.767
R681 GND.n73 GND.n67 117.001
R682 GND.n67 GND.n8 117.001
R683 GND.n379 GND.n378 117.001
R684 GND.n378 GND.n377 117.001
R685 GND.n55 GND 117.001
R686 GND.n56 GND.n55 117.001
R687 GND GND.n66 117.001
R688 GND.n66 GND.n65 117.001
R689 GND.n48 GND.n45 117.001
R690 GND.t23 GND.n48 117.001
R691 GND.n47 GND.n46 117.001
R692 GND.t23 GND.n47 117.001
R693 GND.n124 GND.n123 115.895
R694 GND.n181 GND.t21 114.162
R695 GND.n155 GND.n154 107.281
R696 GND.n124 GND.t6 102.668
R697 GND.n328 GND.n327 101.704
R698 GND.n169 GND.n168 97.5005
R699 GND.n170 GND.n169 97.5005
R700 GND.n135 GND.n134 97.5005
R701 GND.n134 GND.n108 97.5005
R702 GND.n132 GND 97.5005
R703 GND.n132 GND.n131 97.5005
R704 GND GND.n165 97.5005
R705 GND.n165 GND.n164 97.5005
R706 GND.n228 GND.n227 97.5005
R707 GND.n229 GND.n228 97.5005
R708 GND GND.n224 97.5005
R709 GND.n224 GND.n223 97.5005
R710 GND.n388 GND.t35 97.3963
R711 GND.n122 GND.t21 92.0258
R712 GND.n76 GND.t7 87.2906
R713 GND.n162 GND.n159 79.7892
R714 GND GND.t24 79.0672
R715 GND.n226 GND.n225 78.655
R716 GND.n167 GND.n166 78.655
R717 GND.n136 GND.n116 78.655
R718 GND.n238 GND.n210 76.8758
R719 GND.n148 GND.n138 76.8758
R720 GND.n178 GND.n98 76.8758
R721 GND.t8 GND.n108 76.2196
R722 GND.n174 GND.n173 73.1255
R723 GND.n173 GND.t3 73.1255
R724 GND.n172 GND.n171 73.1255
R725 GND.t3 GND.n172 73.1255
R726 GND.n152 GND.n110 73.1255
R727 GND.t8 GND.n110 73.1255
R728 GND.n111 GND.n109 73.1255
R729 GND.t8 GND.n109 73.1255
R730 GND.n127 GND.n120 73.1255
R731 GND.n120 GND.t6 73.1255
R732 GND.n121 GND.n119 73.1255
R733 GND.n119 GND.t6 73.1255
R734 GND.n5 GND.n2 73.1255
R735 GND.t13 GND.n5 73.1255
R736 GND.n4 GND.n3 73.1255
R737 GND.t13 GND.n4 73.1255
R738 GND.n214 GND.n211 73.1255
R739 GND.t5 GND.n214 73.1255
R740 GND.n213 GND.n212 73.1255
R741 GND.t5 GND.n213 73.1255
R742 GND.n14 GND.n12 73.1255
R743 GND.n12 GND.t35 73.1255
R744 GND.n13 GND.n11 73.1255
R745 GND.n11 GND.t35 73.1255
R746 GND.t5 GND.n229 72.2971
R747 GND.n143 GND.t8 71.6177
R748 GND.n170 GND.n104 71.3183
R749 GND.n131 GND.t6 68.7325
R750 GND.n231 GND.t5 67.932
R751 GND.n223 GND.t35 65.2039
R752 GND.n235 GND.n211 64.0758
R753 GND.n175 GND.n174 64.0758
R754 GND.n152 GND.n151 64.0758
R755 GND.n164 GND.n163 62.747
R756 GND.n395 GND.n2 59.6711
R757 GND.n127 GND.n126 59.6711
R758 GND.n386 GND.n14 59.6711
R759 GND.t19 GND.n156 56.8447
R760 GND.n77 GND.n56 56.1431
R761 GND.n247 GND.n246 54.7051
R762 GND.n367 GND.n247 54.7051
R763 GND.t23 GND.n94 54.3316
R764 GND.n183 GND.t23 52.6742
R765 GND.n32 GND.n23 50.0822
R766 GND.n38 GND.n35 50.0822
R767 GND.n294 GND.n248 47.5139
R768 GND.n332 GND.n330 47.5139
R769 GND.n64 GND.t4 46.1497
R770 GND.t4 GND.n54 46.1497
R771 GND.n85 GND.t29 46.0377
R772 GND.n86 GND.t14 46.0377
R773 GND.n92 GND.t14 46.0377
R774 GND.n166 GND.n106 41.7862
R775 GND.n107 GND.n105 41.7862
R776 GND.n157 GND.n105 41.7862
R777 GND.n133 GND.n116 41.7862
R778 GND.n133 GND.t33 41.7862
R779 GND.n118 GND.n117 41.7862
R780 GND.n118 GND.t33 41.7862
R781 GND.n145 GND.n138 41.7862
R782 GND.n145 GND.t31 41.7862
R783 GND.n140 GND.n139 41.7862
R784 GND.t31 GND.n140 41.7862
R785 GND.n210 GND.n208 41.7862
R786 GND.n208 GND.t25 41.7862
R787 GND.n209 GND.n207 41.7862
R788 GND.n207 GND.t25 41.7862
R789 GND.n225 GND.n218 41.7862
R790 GND.t27 GND.n218 41.7862
R791 GND.n219 GND.n217 41.7862
R792 GND.t27 GND.n217 41.7862
R793 GND.n98 GND.n96 41.7862
R794 GND.n96 GND.t21 41.7862
R795 GND.n97 GND.n95 41.7862
R796 GND.n95 GND.t21 41.7862
R797 GND.n382 GND.n381 34.2429
R798 GND.n131 GND.n130 33.9351
R799 GND.n223 GND.n222 32.193
R800 GND.n143 GND.n142 31.0634
R801 GND.n232 GND.n231 29.4648
R802 GND.n79 GND.n78 29.3576
R803 GND.n163 GND.n162 28.6625
R804 GND.n60 GND.n59 26.5914
R805 GND.n59 GND.n54 26.5914
R806 GND.n63 GND 26.5914
R807 GND.n64 GND.n63 26.5914
R808 GND.n91 GND.n90 26.5914
R809 GND.n92 GND.n91 26.5914
R810 GND GND.n87 26.5914
R811 GND.n87 GND.n86 26.5914
R812 GND.n154 GND.n108 26.4615
R813 GND.n229 GND.n216 25.0997
R814 GND.n123 GND.n103 24.0315
R815 GND.n270 GND.n268 23.6288
R816 GND.n356 GND.n258 23.6288
R817 GND.n285 GND.n284 23.6288
R818 GND.n189 GND.n43 22.9908
R819 GND GND.t22 21.1687
R820 GND GND.t26 21.1687
R821 GND GND.t32 21.1687
R822 GND GND.t34 21.1687
R823 GND GND.t28 21.1687
R824 GND GND.t20 21.1687
R825 GND.n193 GND.n0 19.5005
R826 GND.n363 GND.n252 18.8005
R827 GND.n203 GND.n202 17.9733
R828 GND.n78 GND.t29 16.6806
R829 GND.n123 GND.n122 15.7821
R830 GND.n41 GND 15.035
R831 GND.n288 GND 14.9453
R832 GND.n188 GND.n44 14.7876
R833 GND.n396 GND.n395 14.51
R834 GND.n126 GND.n115 14.51
R835 GND.n386 GND.n385 14.51
R836 GND.n42 GND 13.9564
R837 GND.n81 GND.n42 13.8005
R838 GND.n373 GND.n372 13.3171
R839 GND.n236 GND.n235 13.2322
R840 GND.n176 GND.n175 13.2322
R841 GND.n151 GND.n150 13.2322
R842 GND.n238 GND.n237 12.0794
R843 GND.n149 GND.n148 12.0794
R844 GND.n178 GND.n177 12.0794
R845 GND.n226 GND.n15 11.6628
R846 GND.n167 GND.n1 11.6628
R847 GND.n137 GND.n136 11.6628
R848 GND.n188 GND.n187 11.3408
R849 GND.n192 GND.n191 11.3048
R850 GND.n383 GND.n382 11.1369
R851 GND.n327 GND.n295 10.2737
R852 GND.n312 GND.n300 10.2737
R853 GND.n321 GND.n320 10.2737
R854 GND.n17 GND.t2 10.1864
R855 GND.n199 GND 9.75018
R856 GND.n84 GND.n83 9.59066
R857 GND.n85 GND.n84 9.59066
R858 GND GND.n80 9.59066
R859 GND.n80 GND.n79 9.59066
R860 GND.n202 GND.n201 9.58257
R861 GND.n363 GND.n362 9.02014
R862 GND.n336 GND.n335 9.01568
R863 GND.n159 GND.n158 8.83584
R864 GND.n361 GND.n204 8.53072
R865 GND.n17 GND 8.2161
R866 GND.n177 GND 8.15682
R867 GND.n237 GND 8.15682
R868 GND.n149 GND 8.15682
R869 GND.n189 GND.n188 7.94494
R870 GND.n31 GND.n29 7.8005
R871 GND.n33 GND.n31 7.8005
R872 GND.n30 GND.n28 7.8005
R873 GND.n30 GND.n23 7.8005
R874 GND.n34 GND.n27 7.8005
R875 GND.n35 GND.n34 7.8005
R876 GND.n375 GND.n374 7.8005
R877 GND.n376 GND.n375 7.8005
R878 GND.n307 GND.n301 7.8005
R879 GND.n311 GND.n301 7.8005
R880 GND.n310 GND.n309 7.8005
R881 GND.n311 GND.n310 7.8005
R882 GND.n358 GND.n357 7.8005
R883 GND.n357 GND.n356 7.8005
R884 GND.n355 GND.n354 7.8005
R885 GND.n356 GND.n355 7.8005
R886 GND.n329 GND.n252 7.8005
R887 GND.n330 GND.n329 7.8005
R888 GND.n365 GND.n364 7.8005
R889 GND.n366 GND.n365 7.8005
R890 GND.n266 GND.n263 7.8005
R891 GND.n298 GND.n266 7.8005
R892 GND.n265 GND.n264 7.8005
R893 GND.n298 GND.n265 7.8005
R894 GND.n349 GND.n259 7.8005
R895 GND.n353 GND.n259 7.8005
R896 GND.n352 GND.n351 7.8005
R897 GND.n353 GND.n352 7.8005
R898 GND.n293 GND.n290 7.8005
R899 GND.n328 GND.n293 7.8005
R900 GND.n292 GND.n291 7.8005
R901 GND.n292 GND.n248 7.8005
R902 GND.n324 GND.n297 7.8005
R903 GND.n300 GND.n297 7.8005
R904 GND.n323 GND.n296 7.8005
R905 GND.n300 GND.n296 7.8005
R906 GND.n276 GND.n273 7.8005
R907 GND.n273 GND.n272 7.8005
R908 GND.n274 GND.n269 7.8005
R909 GND.n272 GND.n269 7.8005
R910 GND.n316 GND.n313 7.8005
R911 GND.n313 GND.n312 7.8005
R912 GND.n314 GND.n299 7.8005
R913 GND.n312 GND.n299 7.8005
R914 GND.n283 GND.n278 7.8005
R915 GND.n283 GND.n258 7.8005
R916 GND.n280 GND.n279 7.8005
R917 GND.n280 GND.n258 7.8005
R918 GND.n271 GND.n270 7.70538
R919 GND.n356 GND.n353 7.70538
R920 GND.n200 GND.n193 7.55732
R921 GND.n366 GND.n248 7.19172
R922 GND.n332 GND.n294 7.19172
R923 GND.n330 GND.n328 7.19172
R924 GND.n304 GND.n303 6.67806
R925 GND.n311 GND.n298 6.67806
R926 GND.n343 GND.n267 6.67806
R927 GND.n187 GND 6.31877
R928 GND.n360 GND.n254 6.23889
R929 GND.n347 GND.n346 6.23443
R930 GND.n187 GND.n186 6.1505
R931 GND.n338 GND.n277 6.13175
R932 GND.n339 GND.n338 6.04246
R933 GND.n360 GND.n359 5.788
R934 GND.n348 GND.n347 5.77907
R935 GND.n199 GND.n198 5.71965
R936 GND.n371 GND.n370 5.71657
R937 GND.n289 GND.n288 5.70139
R938 GND.n113 GND.n16 5.46641
R939 GND.n317 GND.n289 5.06211
R940 GND.n382 GND.n16 4.97777
R941 GND.n376 GND.n23 4.62343
R942 GND.n38 GND.n32 4.62343
R943 GND.n35 GND.n33 4.62343
R944 GND.n342 GND.n268 4.62343
R945 GND.n272 GND.n258 4.62343
R946 GND.n285 GND.n260 4.62343
R947 GND.n191 GND 4.59738
R948 GND.n0 GND 4.59112
R949 GND.n383 GND 4.59112
R950 GND.n113 GND 4.59112
R951 GND.n201 GND 4.588
R952 GND.n115 GND.n114 4.5005
R953 GND.n385 GND.n384 4.5005
R954 GND.n190 GND.n189 4.5005
R955 GND.n397 GND.n396 4.5005
R956 GND.n193 GND.n192 4.5005
R957 GND.n41 GND.n40 4.2255
R958 GND.t31 GND.n6 3.92082
R959 GND.n65 GND.n56 3.59939
R960 GND.n114 GND 3.52071
R961 GND.n384 GND 3.52071
R962 GND GND.n397 3.52071
R963 GND.n336 GND.n253 3.438
R964 GND.n372 GND.n41 3.42945
R965 GND.n200 GND.n199 3.4105
R966 GND.n155 GND.t33 3.16461
R967 GND.n192 GND.n16 3.02323
R968 GND.n194 GND.t18 2.96409
R969 GND.n369 GND.n368 2.9402
R970 GND.n368 GND.n367 2.9402
R971 GND.n245 GND.n244 2.9402
R972 GND.n246 GND.n245 2.9402
R973 GND.n198 GND.n197 2.89281
R974 GND.n197 GND.n196 2.89281
R975 GND.n196 GND 2.89281
R976 GND.n195 GND.n194 2.89281
R977 GND GND.n195 2.89281
R978 GND.n362 GND.n361 2.74157
R979 GND.n94 GND.n92 2.66932
R980 GND.n72 GND.n18 2.62707
R981 GND.n288 GND.n287 2.6105
R982 GND.n377 GND.n8 2.56879
R983 GND.n203 GND 2.33487
R984 GND.n381 GND.n380 2.2355
R985 GND.n22 GND.n19 2.12777
R986 GND.n21 GND.n20 2.12777
R987 GND.n68 GND.n21 2.12777
R988 GND.n71 GND.n70 2.12777
R989 GND.n70 GND.n69 2.12777
R990 GND.n75 GND.n74 2.12777
R991 GND.n372 GND.n371 2.07193
R992 GND.n335 GND.n290 2.0485
R993 GND.n337 GND.n289 2.04514
R994 GND.n362 GND.n253 1.99157
R995 GND.n337 GND.n336 1.53621
R996 GND.t7 GND.n7 1.45884
R997 GND.n201 GND.n200 1.10845
R998 GND.n371 GND.n204 1.10558
R999 GND.n236 GND.n15 1.05606
R1000 GND.n150 GND.n137 1.05606
R1001 GND.n176 GND.n1 1.05606
R1002 GND.n304 GND.n295 1.02782
R1003 GND.n312 GND.n311 1.02782
R1004 GND.n320 GND.n267 1.02782
R1005 GND.n202 GND 0.931094
R1006 GND.n204 GND.n203 0.925723
R1007 GND.n82 GND.n81 0.873227
R1008 GND.n237 GND.n236 0.833833
R1009 GND.n150 GND.n149 0.833833
R1010 GND.n177 GND.n176 0.833833
R1011 GND.n370 GND 0.776258
R1012 GND.n40 GND 0.6405
R1013 GND.n18 GND.n17 0.576636
R1014 GND.n338 GND.n337 0.5005
R1015 GND.n347 GND.n253 0.5005
R1016 GND.n361 GND.n360 0.5005
R1017 GND.n114 GND.n113 0.361611
R1018 GND.n384 GND.n383 0.361611
R1019 GND.n397 GND.n0 0.361611
R1020 GND.n385 GND.n15 0.319944
R1021 GND.n137 GND.n115 0.319944
R1022 GND.n396 GND.n1 0.319944
R1023 GND.n190 GND.n42 0.285222
R1024 GND.n186 GND.n45 0.237537
R1025 GND.n191 GND.n190 0.236611
R1026 GND.n381 GND.n18 0.119345
R1027 GND GND.t9 0.0717857
R1028 GND.n196 GND.t10 0.0717857
R1029 GND.n197 GND.t11 0.0717857
R1030 GND.n198 GND.t12 0.0717857
R1031 GND GND.t15 0.0717857
R1032 GND.n195 GND.t16 0.0717857
R1033 GND.n194 GND.t17 0.0717857
R1034 GND.n7 GND.t1 0.0382273
C0 VDD out 2.20737f
C1 x1.x2.XM4.G x1.x4.VINN 0
C2 x1.x4.XM5.S out 0.09606f
C3 VDD x1.x4.XM4.G 5.41879f
C4 VDD x1.x3.XM5.S 0.2606f
C5 x1.x4.XM4.G x1.x4.XM5.S 0.00852f
C6 x1.x3.XM4.G x1.x4.VINN 0.11055f
C7 VDD x1.x4.XM5.S 0.10797f
C8 x1.x1.XM4.G x1.x4.VINN 0.11054f
C9 VDD x5.XR9.R2 0.01198f
C10 x1.x2.XM4.G x1.XC1.C1 0.1106f
C11 x1.x1.XM5.S x1.x1.XM4.G 0.27385f
C12 x1.x2.XM4.G x1.x2.XM5.S 0.27385f
C13 x1.x1.XM5.S x1.x4.VINN 0.04708f
C14 x1.x3.XM4.G x1.XC1.C1 0.13418f
C15 x1.x2.XM4.G out 0.13416f
C16 x1.x1.XM4.G x5.out 0.0026f
C17 x5.out x1.x4.VINN 0.16858f
C18 x1.x1.XM4.G x1.XC1.C1 0.13416f
C19 x1.XC1.C1 x1.x4.VINN 0.00538f
C20 x1.x3.XM4.G out 0
C21 VDD x1.x2.XM4.G 2.01573f
C22 x1.x1.XM5.S x5.out 0.04307f
C23 x1.x3.XM4.G x1.x3.XM5.S 0.27385f
C24 x1.x2.XM5.S x1.x4.VINN 0.04303f
C25 x1.x1.XM5.S x1.XC1.C1 0.22466f
C26 out x1.x4.VINN 2.03058f
C27 VDD x1.x3.XM4.G 2.01633f
C28 x1.x4.XM4.G x1.x4.VINN 0.00496f
C29 x5.out x1.XC1.C1 0.54985f
C30 x1.x4.VINN x1.x3.XM5.S 0.04708f
C31 VDD x1.x1.XM4.G 2.01573f
C32 VDD x1.x4.VINN 3.37439f
C33 x1.x4.XM5.S x1.x4.VINN 0.05561f
C34 x1.x2.XM5.S x1.XC1.C1 0.04708f
C35 out x1.XC1.C1 0.46771f
C36 VDD x1.x1.XM5.S 0.2606f
C37 x1.XC1.C1 x1.x3.XM5.S 0.22466f
C38 out x1.x2.XM5.S 0.22466f
C39 VDD x5.XR2.R1 0.02329f
C40 VDD x5.out 0.40136f
C41 VDD x1.XC1.C1 2.6653f
C42 x1.x4.XM4.G out 0.14775f
C43 out x1.x3.XM5.S 0.04311f
C44 x5.out x5.XR9.R2 0.02489f
C45 VDD x1.x2.XM5.S 0.2606f
C46 out GND 0.36231p
C47 b2 GND 2.07542f
C48 b1 GND 1.98306f
C49 b0 GND 1.98762f
C50 VDD GND 0.20068p
C51 x1.x2.XM5.S GND 2.43033f
C52 x1.x2.XM4.G GND 1.28256f
C53 x1.x1.XM5.S GND 2.43017f
C54 x1.x1.XM4.G GND 1.2784f
C55 x1.x4.XM5.S GND 2.77911f
C56 x1.x4.XM4.G GND 4.26474f
C57 x1.x3.XM5.S GND 2.43017f
C58 x1.XC1.C1 GND 0.33611p
C59 x1.x3.XM4.G GND 1.28178f
C60 x1.x4.VINN GND 29.3835f
C61 x5.out GND 21.3402f
C62 x5.XR11.R2 GND 5.63866f
C63 x5.XR8.R1 GND 2.95964f
C64 x5.XR6.R1 GND 3.00093f
C65 x5.XR10.R1 GND 4.66087f
C66 x5.XR4.R2 GND 2.99589f
C67 x5.XR9.R2 GND 4.61157f
C68 x5.XR2.R1 GND 2.65504f
C69 VDD.t0 GND 0.00478f
C70 VDD.n0 GND 0.03498f
C71 VDD.t7 GND 0.00148f
C72 VDD.n1 GND 0.00524f
C73 VDD.t6 GND 0.07248f
C74 VDD.n3 GND 0.04961f
C75 VDD.n4 GND 0.00536f
C76 VDD.n5 GND 0.00536f
C77 VDD.n7 GND 0.04961f
C78 VDD.n8 GND 0.00536f
C79 VDD.n9 GND 0.00285f
C80 VDD.n10 GND 0.00319f
C81 VDD.n11 GND 0.01194f
C82 VDD.t13 GND 0.00137f
C83 VDD.t26 GND 0.13321f
C84 VDD.t12 GND 0.00434f
C85 VDD.n12 GND 0.02391f
C86 VDD.n13 GND 0.06404f
C87 VDD.t9 GND 0.00148f
C88 VDD.n14 GND 0.00274f
C89 VDD.n15 GND 0.00536f
C90 VDD.n16 GND 0.00536f
C91 VDD.t8 GND 0.07248f
C92 VDD.n18 GND 0.04961f
C93 VDD.n19 GND 0.00536f
C94 VDD.n21 GND 0.04961f
C95 VDD.n22 GND 0.00524f
C96 VDD.n23 GND 0.00317f
C97 VDD.n24 GND 0.00776f
C98 VDD.n25 GND 0.03737f
C99 VDD.n26 GND 0.02524f
C100 VDD.n27 GND 0.06726f
C101 VDD.t17 GND 0.00553f
C102 VDD.t16 GND 0.00949f
C103 VDD.t29 GND 0.03309f
C104 VDD.n28 GND 0.02269f
C105 VDD.n29 GND 0.04637f
C106 VDD.t5 GND 0.00744f
C107 VDD.n30 GND 0.00395f
C108 VDD.n31 GND 0.02971f
C109 VDD.n32 GND 0.02971f
C110 VDD.n33 GND 0.00407f
C111 VDD.n34 GND 0.00407f
C112 VDD.t4 GND 0.04864f
C113 VDD.n37 GND 0.00407f
C114 VDD.n38 GND 0.00224f
C115 VDD.n39 GND 0.00329f
C116 VDD.n40 GND 0.01108f
C117 VDD.n41 GND 0.02561f
C118 VDD.t3 GND 0.00744f
C119 VDD.n42 GND 0.00222f
C120 VDD.n43 GND 0.00407f
C121 VDD.n44 GND 0.00407f
C122 VDD.t2 GND 0.04864f
C123 VDD.n45 GND 0.00416f
C124 VDD.n47 GND 0.02971f
C125 VDD.n48 GND 0.00407f
C126 VDD.n50 GND 0.02971f
C127 VDD.n51 GND 0.00279f
C128 VDD.n52 GND 0.01257f
C129 VDD.n53 GND 0.01981f
C130 VDD.n54 GND 0.02796f
C131 VDD.n55 GND 0.12217f
C132 VDD.t21 GND 0.00744f
C133 VDD.n56 GND 0.00416f
C134 VDD.n57 GND 0.02971f
C135 VDD.n58 GND 0.02971f
C136 VDD.n59 GND 0.00407f
C137 VDD.n60 GND 0.00407f
C138 VDD.t20 GND 0.04864f
C139 VDD.n63 GND 0.00407f
C140 VDD.n64 GND 0.00222f
C141 VDD.n65 GND 0.00279f
C142 VDD.n66 GND 0.01257f
C143 VDD.t11 GND 0.00553f
C144 VDD.t27 GND 0.03309f
C145 VDD.t10 GND 0.00949f
C146 VDD.n67 GND 0.02269f
C147 VDD.n68 GND 0.04637f
C148 VDD.t19 GND 0.00744f
C149 VDD.n69 GND 0.00224f
C150 VDD.n70 GND 0.00407f
C151 VDD.n71 GND 0.00407f
C152 VDD.t18 GND 0.04864f
C153 VDD.n73 GND 0.02971f
C154 VDD.n74 GND 0.00407f
C155 VDD.n76 GND 0.02971f
C156 VDD.n77 GND 0.00395f
C157 VDD.n78 GND 0.00329f
C158 VDD.n79 GND 0.01108f
C159 VDD.n80 GND 0.02561f
C160 VDD.n81 GND 0.01981f
C161 VDD.n82 GND 0.09871f
C162 VDD.n83 GND 0.15603f
C163 VDD.t23 GND 0.00744f
C164 VDD.n84 GND 0.00416f
C165 VDD.n85 GND 0.02971f
C166 VDD.n86 GND 0.02971f
C167 VDD.n87 GND 0.00407f
C168 VDD.n88 GND 0.00407f
C169 VDD.t22 GND 0.04864f
C170 VDD.n91 GND 0.00407f
C171 VDD.n92 GND 0.00222f
C172 VDD.n93 GND 0.00279f
C173 VDD.n94 GND 0.01257f
C174 VDD.t15 GND 0.00553f
C175 VDD.t28 GND 0.03309f
C176 VDD.t14 GND 0.00949f
C177 VDD.n95 GND 0.02269f
C178 VDD.n96 GND 0.04637f
C179 VDD.t25 GND 0.00744f
C180 VDD.n97 GND 0.00224f
C181 VDD.n98 GND 0.00407f
C182 VDD.n99 GND 0.00407f
C183 VDD.t24 GND 0.04864f
C184 VDD.n101 GND 0.02971f
C185 VDD.n102 GND 0.00407f
C186 VDD.n104 GND 0.02971f
C187 VDD.n105 GND 0.00395f
C188 VDD.n106 GND 0.00329f
C189 VDD.n107 GND 0.01108f
C190 VDD.n108 GND 0.02561f
C191 VDD.n109 GND 0.01981f
C192 VDD.n110 GND 0.07997f
C193 VDD.n111 GND 0.11464f
C194 VDD.n112 GND 0.03593f
C195 VDD.t1 GND 0.00849f
C196 VDD.n113 GND 0.08504f
C197 VDD.n114 GND 15.5144f
C198 out.t3 GND 0
C199 out.t1 GND 0
C200 out.n0 GND 0.0012f
C201 out.t8 GND 0.00604f
C202 out.t9 GND 0
C203 out.n1 GND 0.01332f
C204 out.n2 GND 0.02225f
C205 out.t2 GND 0
C206 out.t0 GND 0
C207 out.n3 GND 0.00121f
C208 out.n4 GND 0.02311f
C209 out.t4 GND 1.29384f
C210 out.t5 GND 0.65639f
C211 out.n5 GND 0.64234f
C212 out.t6 GND 0.65639f
C213 out.n6 GND 0.64034f
C214 out.t7 GND 0.65639f
C215 out.n7 GND 0.0301f
.ends
